** Multiplication & Addition Module

** Include VMA netlist
.INCLUDE "/home/centos/EE213/MyLibPDK45/myMAC_64_3bit_4bit/backend/pex/myMAC_64_3bit_4bit.pex.netlist"

***********************************
* Set period time here
***********************************
.PARAM
+ period = 500n

** Instantiate your MAC module here
*   The MAC module does vector inner product of two 64d vectors. The multiplier(i.e. weight) and multiplicand(i.e. input) is
*   quantized to 3bit and 4bit signed integer respectively. The output is a single 12bit signed integer.
*	The following content describes the pins needed in MAC module and the corresponding internal signals they should be connected to
*	Format:
*		<module_pin_name> -> <testbench_signal_name> : <description>
*		"->" means connect to
*
*	Your top module should have the following pins
*	Output:
*       OUT<11:0> -> result<11:0>: The output result of MAC module
*	Inputs:
*       MULTIPLIER<191:0> -> multiplier<191:0>: The 64*3bit multiplier
*       MULTIPLICAND<255:0> -> multiplicand<255:0>: The 64*4bit multiplicand

** Here is an example of the instance. The order of signals may vary with your design.
** Please connect the signals correctly. (Do not modify the instance name when you instantiate your module)
xmac VDD! MULTIPLICAND<194> MULTIPLICAND<195>
+ MULTIPLICAND<198> MULTIPLICAND<199> MULTIPLICAND<202> MULTIPLICAND<203>
+ MULTIPLICAND<206> MULTIPLICAND<207> MULTIPLICAND<210> MULTIPLICAND<211>
+ MULTIPLICAND<214> MULTIPLICAND<215> MULTIPLICAND<218> MULTIPLICAND<219>
+ MULTIPLICAND<222> MULTIPLICAND<223> MULTIPLICAND<226> MULTIPLICAND<227>
+ MULTIPLICAND<230> MULTIPLICAND<231> MULTIPLICAND<234> MULTIPLICAND<235>
+ MULTIPLICAND<238> MULTIPLICAND<239> MULTIPLICAND<242> MULTIPLICAND<243>
+ MULTIPLICAND<246> MULTIPLICAND<247> MULTIPLICAND<250> MULTIPLICAND<251>
+ MULTIPLICAND<254> MULTIPLICAND<255> MULTIPLICAND<63> MULTIPLICAND<62>
+ MULTIPLICAND<59> MULTIPLICAND<58> MULTIPLICAND<55> MULTIPLICAND<54>
+ MULTIPLICAND<51> MULTIPLICAND<50> MULTIPLICAND<47> MULTIPLICAND<46>
+ MULTIPLICAND<43> MULTIPLICAND<42> MULTIPLICAND<39> MULTIPLICAND<38>
+ MULTIPLICAND<35> MULTIPLICAND<34> MULTIPLICAND<31> MULTIPLICAND<30>
+ MULTIPLICAND<27> MULTIPLICAND<26> MULTIPLICAND<23> MULTIPLICAND<22>
+ MULTIPLICAND<19> MULTIPLICAND<18> MULTIPLICAND<15> MULTIPLICAND<14>
+ MULTIPLICAND<11> MULTIPLICAND<10> MULTIPLICAND<7> MULTIPLICAND<6>
+ MULTIPLICAND<3> MULTIPLICAND<2> MULTIPLICAND<193> MULTIPLICAND<197>
+ MULTIPLICAND<201> MULTIPLICAND<205> MULTIPLICAND<209> MULTIPLICAND<213>
+ MULTIPLICAND<217> MULTIPLICAND<221> MULTIPLICAND<225> MULTIPLICAND<229>
+ MULTIPLICAND<233> MULTIPLICAND<237> MULTIPLICAND<241> MULTIPLICAND<245>
+ MULTIPLICAND<249> MULTIPLICAND<253> MULTIPLICAND<61> MULTIPLICAND<57>
+ MULTIPLICAND<53> MULTIPLICAND<49> MULTIPLICAND<45> MULTIPLICAND<41>
+ MULTIPLICAND<37> MULTIPLICAND<33> MULTIPLICAND<29> MULTIPLICAND<25>
+ MULTIPLICAND<21> MULTIPLICAND<17> MULTIPLICAND<13> MULTIPLICAND<9>
+ MULTIPLICAND<5> MULTIPLICAND<1> MULTIPLIER<144> MULTIPLIER<147>
+ MULTIPLIER<150> MULTIPLIER<153> MULTIPLIER<156> MULTIPLIER<159>
+ MULTIPLIER<162> MULTIPLIER<165> MULTIPLIER<168> MULTIPLIER<171>
+ MULTIPLIER<174> MULTIPLIER<177> MULTIPLIER<180> MULTIPLIER<183>
+ MULTIPLIER<186> MULTIPLIER<189> MULTIPLIER<45> MULTIPLIER<42> MULTIPLIER<39>
+ MULTIPLIER<36> MULTIPLIER<33> MULTIPLIER<30> MULTIPLIER<27> MULTIPLIER<24>
+ MULTIPLIER<21> MULTIPLIER<18> MULTIPLIER<15> MULTIPLIER<12> MULTIPLIER<9>
+ MULTIPLIER<6> MULTIPLIER<3> MULTIPLIER<0> GND! MULTIPLIER<145> MULTIPLIER<148>
+ MULTIPLIER<151> MULTIPLIER<154> MULTIPLIER<157> MULTIPLIER<160>
+ MULTIPLIER<163> MULTIPLIER<166> MULTIPLIER<169> MULTIPLIER<172>
+ MULTIPLIER<175> MULTIPLIER<178> MULTIPLIER<181> MULTIPLIER<184>
+ MULTIPLIER<187> MULTIPLIER<190> MULTIPLIER<46> MULTIPLIER<43> MULTIPLIER<40>
+ MULTIPLIER<37> MULTIPLIER<34> MULTIPLIER<31> MULTIPLIER<28> MULTIPLIER<25>
+ MULTIPLIER<22> MULTIPLIER<19> MULTIPLIER<16> MULTIPLIER<13> MULTIPLIER<10>
+ MULTIPLIER<7> MULTIPLIER<4> MULTIPLIER<1> MULTIPLICAND<192> MULTIPLICAND<196>
+ MULTIPLICAND<200> MULTIPLICAND<204> MULTIPLICAND<208> MULTIPLICAND<212>
+ MULTIPLICAND<216> MULTIPLICAND<220> MULTIPLICAND<224> MULTIPLICAND<228>
+ MULTIPLICAND<232> MULTIPLICAND<236> MULTIPLICAND<240> MULTIPLICAND<244>
+ MULTIPLICAND<248> MULTIPLICAND<252> MULTIPLICAND<60> MULTIPLICAND<56>
+ MULTIPLICAND<52> MULTIPLICAND<48> MULTIPLICAND<44> MULTIPLICAND<40>
+ MULTIPLICAND<36> MULTIPLICAND<32> MULTIPLICAND<28> MULTIPLICAND<24>
+ MULTIPLICAND<20> MULTIPLICAND<16> MULTIPLICAND<12> MULTIPLICAND<8>
+ MULTIPLICAND<4> MULTIPLICAND<0> MULTIPLIER<146> MULTIPLIER<149>
+ MULTIPLIER<152> MULTIPLIER<155> MULTIPLIER<158> MULTIPLIER<161>
+ MULTIPLIER<164> MULTIPLIER<167> MULTIPLIER<170> MULTIPLIER<173>
+ MULTIPLIER<176> MULTIPLIER<179> MULTIPLIER<182> MULTIPLIER<185>
+ MULTIPLIER<188> MULTIPLIER<191> MULTIPLIER<47> MULTIPLIER<44> MULTIPLIER<41>
+ MULTIPLIER<38> MULTIPLIER<35> MULTIPLIER<32> MULTIPLIER<29> MULTIPLIER<26>
+ MULTIPLIER<23> MULTIPLIER<20> MULTIPLIER<17> MULTIPLIER<14> MULTIPLIER<11>
+ MULTIPLIER<8> MULTIPLIER<5> MULTIPLIER<2> RESULT<11> RESULT<10> RESULT<9>
+ RESULT<8> RESULT<7> RESULT<6> RESULT<5> RESULT<4> RESULT<3> RESULT<2>
+ RESULT<1> RESULT<0> MULTIPLIER<98> MULTIPLIER<101> MULTIPLIER<104>
+ MULTIPLIER<107> MULTIPLIER<110> MULTIPLIER<113> MULTIPLIER<116>
+ MULTIPLIER<119> MULTIPLIER<122> MULTIPLIER<125> MULTIPLIER<128>
+ MULTIPLIER<131> MULTIPLIER<134> MULTIPLIER<137> MULTIPLIER<140>
+ MULTIPLIER<143> MULTIPLIER<95> MULTIPLIER<92> MULTIPLIER<89> MULTIPLIER<86>
+ MULTIPLIER<83> MULTIPLIER<80> MULTIPLIER<77> MULTIPLIER<74> MULTIPLIER<71>
+ MULTIPLIER<68> MULTIPLIER<65> MULTIPLIER<62> MULTIPLIER<59> MULTIPLIER<56>
+ MULTIPLIER<53> MULTIPLIER<50> MULTIPLICAND<128> MULTIPLICAND<132>
+ MULTIPLICAND<136> MULTIPLICAND<140> MULTIPLICAND<144> MULTIPLICAND<148>
+ MULTIPLICAND<152> MULTIPLICAND<156> MULTIPLICAND<160> MULTIPLICAND<164>
+ MULTIPLICAND<168> MULTIPLICAND<172> MULTIPLICAND<176> MULTIPLICAND<180>
+ MULTIPLICAND<184> MULTIPLICAND<188> MULTIPLICAND<124> MULTIPLICAND<120>
+ MULTIPLICAND<116> MULTIPLICAND<112> MULTIPLICAND<108> MULTIPLICAND<104>
+ MULTIPLICAND<100> MULTIPLICAND<96> MULTIPLICAND<92> MULTIPLICAND<88>
+ MULTIPLICAND<84> MULTIPLICAND<80> MULTIPLICAND<76> MULTIPLICAND<72>
+ MULTIPLICAND<68> MULTIPLICAND<64> MULTIPLIER<97> MULTIPLIER<100>
+ MULTIPLIER<103> MULTIPLIER<106> MULTIPLIER<109> MULTIPLIER<112>
+ MULTIPLIER<115> MULTIPLIER<118> MULTIPLIER<121> MULTIPLIER<124>
+ MULTIPLIER<127> MULTIPLIER<130> MULTIPLIER<133> MULTIPLIER<136>
+ MULTIPLIER<139> MULTIPLIER<142> MULTIPLIER<94> MULTIPLIER<91> MULTIPLIER<88>
+ MULTIPLIER<85> MULTIPLIER<82> MULTIPLIER<79> MULTIPLIER<76> MULTIPLIER<73>
+ MULTIPLIER<70> MULTIPLIER<67> MULTIPLIER<64> MULTIPLIER<61> MULTIPLIER<58>
+ MULTIPLIER<55> MULTIPLIER<52> MULTIPLIER<49> MULTIPLIER<96> MULTIPLIER<99>
+ MULTIPLIER<102> MULTIPLIER<105> MULTIPLIER<108> MULTIPLIER<111>
+ MULTIPLIER<114> MULTIPLIER<117> MULTIPLIER<120> MULTIPLIER<123>
+ MULTIPLIER<126> MULTIPLIER<129> MULTIPLIER<132> MULTIPLIER<135>
+ MULTIPLIER<138> MULTIPLIER<141> MULTIPLIER<93> MULTIPLIER<90> MULTIPLIER<87>
+ MULTIPLIER<84> MULTIPLIER<81> MULTIPLIER<78> MULTIPLIER<75> MULTIPLIER<72>
+ MULTIPLIER<69> MULTIPLIER<66> MULTIPLIER<63> MULTIPLIER<60> MULTIPLIER<57>
+ MULTIPLIER<54> MULTIPLIER<51> MULTIPLIER<48> MULTIPLICAND<129>
+ MULTIPLICAND<133> MULTIPLICAND<137> MULTIPLICAND<141> MULTIPLICAND<145>
+ MULTIPLICAND<149> MULTIPLICAND<153> MULTIPLICAND<157> MULTIPLICAND<161>
+ MULTIPLICAND<165> MULTIPLICAND<169> MULTIPLICAND<173> MULTIPLICAND<177>
+ MULTIPLICAND<181> MULTIPLICAND<185> MULTIPLICAND<189> MULTIPLICAND<125>
+ MULTIPLICAND<121> MULTIPLICAND<117> MULTIPLICAND<113> MULTIPLICAND<109>
+ MULTIPLICAND<105> MULTIPLICAND<101> MULTIPLICAND<97> MULTIPLICAND<93>
+ MULTIPLICAND<89> MULTIPLICAND<85> MULTIPLICAND<81> MULTIPLICAND<77>
+ MULTIPLICAND<73> MULTIPLICAND<69> MULTIPLICAND<65> MULTIPLICAND<130>
+ MULTIPLICAND<131> MULTIPLICAND<134> MULTIPLICAND<135> MULTIPLICAND<138>
+ MULTIPLICAND<139> MULTIPLICAND<142> MULTIPLICAND<143> MULTIPLICAND<146>
+ MULTIPLICAND<147> MULTIPLICAND<150> MULTIPLICAND<151> MULTIPLICAND<154>
+ MULTIPLICAND<155> MULTIPLICAND<158> MULTIPLICAND<159> MULTIPLICAND<162>
+ MULTIPLICAND<163> MULTIPLICAND<166> MULTIPLICAND<167> MULTIPLICAND<170>
+ MULTIPLICAND<171> MULTIPLICAND<174> MULTIPLICAND<175> MULTIPLICAND<178>
+ MULTIPLICAND<179> MULTIPLICAND<182> MULTIPLICAND<183> MULTIPLICAND<186>
+ MULTIPLICAND<187> MULTIPLICAND<190> MULTIPLICAND<191> MULTIPLICAND<127>
+ MULTIPLICAND<126> MULTIPLICAND<123> MULTIPLICAND<122> MULTIPLICAND<119>
+ MULTIPLICAND<118> MULTIPLICAND<115> MULTIPLICAND<114> MULTIPLICAND<111>
+ MULTIPLICAND<110> MULTIPLICAND<107> MULTIPLICAND<106> MULTIPLICAND<103>
+ MULTIPLICAND<102> MULTIPLICAND<99> MULTIPLICAND<98> MULTIPLICAND<95>
+ MULTIPLICAND<94> MULTIPLICAND<91> MULTIPLICAND<90> MULTIPLICAND<87>
+ MULTIPLICAND<86> MULTIPLICAND<83> MULTIPLICAND<82> MULTIPLICAND<79>
+ MULTIPLICAND<78> MULTIPLICAND<75> MULTIPLICAND<74> MULTIPLICAND<71>
+ MULTIPLICAND<70> MULTIPLICAND<67> MULTIPLICAND<66> myMAC_64_3bit_4bit
