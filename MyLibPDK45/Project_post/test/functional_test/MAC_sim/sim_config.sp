** Params
.GLOBAL vdd!
.PARAM vdd_val=0.7 period=5n

.TRAN 1e-12 'period*32' START=0.0

.TEMP 25.0
.OPTION
+    INGOLD=2
+    PARHIER=LOCAL
+    PROBE
+    NOMOD
+    POST=2

.PROBE TRAN
+    V(multiplier<0>)
+    V(multiplier<1>)
+    V(multiplier<2>)
+    V(multiplier<3>)
+    V(multiplier<4>)
+    V(multiplier<5>)
+    V(multiplier<6>)
+    V(multiplier<7>)
+    V(multiplier<8>)
+    V(multiplier<9>)
+    V(multiplier<10>)
+    V(multiplier<11>)
+    V(multiplier<12>)
+    V(multiplier<13>)
+    V(multiplier<14>)
+    V(multiplier<15>)
+    V(multiplier<16>)
+    V(multiplier<17>)
+    V(multiplier<18>)
+    V(multiplier<19>)
+    V(multiplier<20>)
+    V(multiplier<21>)
+    V(multiplier<22>)
+    V(multiplier<23>)
+    V(multiplier<24>)
+    V(multiplier<25>)
+    V(multiplier<26>)
+    V(multiplier<27>)
+    V(multiplier<28>)
+    V(multiplier<29>)
+    V(multiplier<30>)
.PROBE TRAN
+    V(multiplier<31>)
+    V(multiplier<32>)
+    V(multiplier<33>)
+    V(multiplier<34>)
+    V(multiplier<35>)
+    V(multiplier<36>)
+    V(multiplier<37>)
+    V(multiplier<38>)
+    V(multiplier<39>)
+    V(multiplier<40>)
+    V(multiplier<41>)
+    V(multiplier<42>)
+    V(multiplier<43>)
+    V(multiplier<44>)
+    V(multiplier<45>)
+    V(multiplier<46>)
+    V(multiplier<47>)
+    V(multiplier<48>)
+    V(multiplier<49>)
+    V(multiplier<50>)
+    V(multiplier<51>)
+    V(multiplier<52>)
+    V(multiplier<53>)
+    V(multiplier<54>)
+    V(multiplier<55>)
+    V(multiplier<56>)
+    V(multiplier<57>)
+    V(multiplier<58>)
+    V(multiplier<59>)
+    V(multiplier<60>)
+    V(multiplier<61>)
+    V(multiplier<62>)
.PROBE TRAN
+    V(multiplier<63>)
+    V(multiplier<64>)
+    V(multiplier<65>)
+    V(multiplier<66>)
+    V(multiplier<67>)
+    V(multiplier<68>)
+    V(multiplier<69>)
+    V(multiplier<70>)
+    V(multiplier<71>)
+    V(multiplier<72>)
+    V(multiplier<73>)
+    V(multiplier<74>)
+    V(multiplier<75>)
+    V(multiplier<76>)
+    V(multiplier<77>)
+    V(multiplier<78>)
+    V(multiplier<79>)
+    V(multiplier<80>)
+    V(multiplier<81>)
+    V(multiplier<82>)
+    V(multiplier<83>)
+    V(multiplier<84>)
+    V(multiplier<85>)
+    V(multiplier<86>)
+    V(multiplier<87>)
+    V(multiplier<88>)
+    V(multiplier<89>)
+    V(multiplier<90>)
+    V(multiplier<91>)
+    V(multiplier<92>)
+    V(multiplier<93>)
+    V(multiplier<94>)
.PROBE TRAN
+    V(multiplier<95>)
+    V(multiplier<96>)
+    V(multiplier<97>)
+    V(multiplier<98>)
+    V(multiplier<99>)
+    V(multiplier<100>)
+    V(multiplier<101>)
+    V(multiplier<102>)
+    V(multiplier<103>)
+    V(multiplier<104>)
+    V(multiplier<105>)
+    V(multiplier<106>)
+    V(multiplier<107>)
+    V(multiplier<108>)
+    V(multiplier<109>)
+    V(multiplier<110>)
+    V(multiplier<111>)
+    V(multiplier<112>)
+    V(multiplier<113>)
+    V(multiplier<114>)
+    V(multiplier<115>)
+    V(multiplier<116>)
+    V(multiplier<117>)
+    V(multiplier<118>)
+    V(multiplier<119>)
+    V(multiplier<120>)
+    V(multiplier<121>)
+    V(multiplier<122>)
+    V(multiplier<123>)
+    V(multiplier<124>)
+    V(multiplier<125>)
+    V(multiplier<126>)
.PROBE TRAN
+    V(multiplier<127>)
+    V(multiplier<128>)
+    V(multiplier<129>)
+    V(multiplier<130>)
+    V(multiplier<131>)
+    V(multiplier<132>)
+    V(multiplier<133>)
+    V(multiplier<134>)
+    V(multiplier<135>)
+    V(multiplier<136>)
+    V(multiplier<137>)
+    V(multiplier<138>)
+    V(multiplier<139>)
+    V(multiplier<140>)
+    V(multiplier<141>)
+    V(multiplier<142>)
+    V(multiplier<143>)
+    V(multiplier<144>)
+    V(multiplier<145>)
+    V(multiplier<146>)
+    V(multiplier<147>)
+    V(multiplier<148>)
+    V(multiplier<149>)
+    V(multiplier<150>)
+    V(multiplier<151>)
+    V(multiplier<152>)
+    V(multiplier<153>)
+    V(multiplier<154>)
+    V(multiplier<155>)
+    V(multiplier<156>)
+    V(multiplier<157>)
+    V(multiplier<158>)
.PROBE TRAN
+    V(multiplier<159>)
+    V(multiplier<160>)
+    V(multiplier<161>)
+    V(multiplier<162>)
+    V(multiplier<163>)
+    V(multiplier<164>)
+    V(multiplier<165>)
+    V(multiplier<166>)
+    V(multiplier<167>)
+    V(multiplier<168>)
+    V(multiplier<169>)
+    V(multiplier<170>)
+    V(multiplier<171>)
+    V(multiplier<172>)
+    V(multiplier<173>)
+    V(multiplier<174>)
+    V(multiplier<175>)
+    V(multiplier<176>)
+    V(multiplier<177>)
+    V(multiplier<178>)
+    V(multiplier<179>)
+    V(multiplier<180>)
+    V(multiplier<181>)
+    V(multiplier<182>)
+    V(multiplier<183>)
+    V(multiplier<184>)
+    V(multiplier<185>)
+    V(multiplier<186>)
+    V(multiplier<187>)
+    V(multiplier<188>)
+    V(multiplier<189>)
+    V(multiplier<190>)
.PROBE TRAN
+    V(multiplier<191>)
+    V(multiplicand<0>)
+    V(multiplicand<1>)
+    V(multiplicand<2>)
+    V(multiplicand<3>)
+    V(multiplicand<4>)
+    V(multiplicand<5>)
+    V(multiplicand<6>)
+    V(multiplicand<7>)
+    V(multiplicand<8>)
+    V(multiplicand<9>)
+    V(multiplicand<10>)
+    V(multiplicand<11>)
+    V(multiplicand<12>)
+    V(multiplicand<13>)
+    V(multiplicand<14>)
+    V(multiplicand<15>)
+    V(multiplicand<16>)
+    V(multiplicand<17>)
+    V(multiplicand<18>)
+    V(multiplicand<19>)
+    V(multiplicand<20>)
+    V(multiplicand<21>)
+    V(multiplicand<22>)
+    V(multiplicand<23>)
+    V(multiplicand<24>)
+    V(multiplicand<25>)
+    V(multiplicand<26>)
+    V(multiplicand<27>)
+    V(multiplicand<28>)
+    V(multiplicand<29>)
+    V(multiplicand<30>)
.PROBE TRAN
+    V(multiplicand<31>)
+    V(multiplicand<32>)
+    V(multiplicand<33>)
+    V(multiplicand<34>)
+    V(multiplicand<35>)
+    V(multiplicand<36>)
+    V(multiplicand<37>)
+    V(multiplicand<38>)
+    V(multiplicand<39>)
+    V(multiplicand<40>)
+    V(multiplicand<41>)
+    V(multiplicand<42>)
+    V(multiplicand<43>)
+    V(multiplicand<44>)
+    V(multiplicand<45>)
+    V(multiplicand<46>)
+    V(multiplicand<47>)
+    V(multiplicand<48>)
+    V(multiplicand<49>)
+    V(multiplicand<50>)
+    V(multiplicand<51>)
+    V(multiplicand<52>)
+    V(multiplicand<53>)
+    V(multiplicand<54>)
+    V(multiplicand<55>)
+    V(multiplicand<56>)
+    V(multiplicand<57>)
+    V(multiplicand<58>)
+    V(multiplicand<59>)
+    V(multiplicand<60>)
+    V(multiplicand<61>)
+    V(multiplicand<62>)
.PROBE TRAN
+    V(multiplicand<63>)
+    V(multiplicand<64>)
+    V(multiplicand<65>)
+    V(multiplicand<66>)
+    V(multiplicand<67>)
+    V(multiplicand<68>)
+    V(multiplicand<69>)
+    V(multiplicand<70>)
+    V(multiplicand<71>)
+    V(multiplicand<72>)
+    V(multiplicand<73>)
+    V(multiplicand<74>)
+    V(multiplicand<75>)
+    V(multiplicand<76>)
+    V(multiplicand<77>)
+    V(multiplicand<78>)
+    V(multiplicand<79>)
+    V(multiplicand<80>)
+    V(multiplicand<81>)
+    V(multiplicand<82>)
+    V(multiplicand<83>)
+    V(multiplicand<84>)
+    V(multiplicand<85>)
+    V(multiplicand<86>)
+    V(multiplicand<87>)
+    V(multiplicand<88>)
+    V(multiplicand<89>)
+    V(multiplicand<90>)
+    V(multiplicand<91>)
+    V(multiplicand<92>)
+    V(multiplicand<93>)
+    V(multiplicand<94>)
.PROBE TRAN
+    V(multiplicand<95>)
+    V(multiplicand<96>)
+    V(multiplicand<97>)
+    V(multiplicand<98>)
+    V(multiplicand<99>)
+    V(multiplicand<100>)
+    V(multiplicand<101>)
+    V(multiplicand<102>)
+    V(multiplicand<103>)
+    V(multiplicand<104>)
+    V(multiplicand<105>)
+    V(multiplicand<106>)
+    V(multiplicand<107>)
+    V(multiplicand<108>)
+    V(multiplicand<109>)
+    V(multiplicand<110>)
+    V(multiplicand<111>)
+    V(multiplicand<112>)
+    V(multiplicand<113>)
+    V(multiplicand<114>)
+    V(multiplicand<115>)
+    V(multiplicand<116>)
+    V(multiplicand<117>)
+    V(multiplicand<118>)
+    V(multiplicand<119>)
+    V(multiplicand<120>)
+    V(multiplicand<121>)
+    V(multiplicand<122>)
+    V(multiplicand<123>)
+    V(multiplicand<124>)
+    V(multiplicand<125>)
+    V(multiplicand<126>)
.PROBE TRAN
+    V(multiplicand<127>)
+    V(multiplicand<128>)
+    V(multiplicand<129>)
+    V(multiplicand<130>)
+    V(multiplicand<131>)
+    V(multiplicand<132>)
+    V(multiplicand<133>)
+    V(multiplicand<134>)
+    V(multiplicand<135>)
+    V(multiplicand<136>)
+    V(multiplicand<137>)
+    V(multiplicand<138>)
+    V(multiplicand<139>)
+    V(multiplicand<140>)
+    V(multiplicand<141>)
+    V(multiplicand<142>)
+    V(multiplicand<143>)
+    V(multiplicand<144>)
+    V(multiplicand<145>)
+    V(multiplicand<146>)
+    V(multiplicand<147>)
+    V(multiplicand<148>)
+    V(multiplicand<149>)
+    V(multiplicand<150>)
+    V(multiplicand<151>)
+    V(multiplicand<152>)
+    V(multiplicand<153>)
+    V(multiplicand<154>)
+    V(multiplicand<155>)
+    V(multiplicand<156>)
+    V(multiplicand<157>)
+    V(multiplicand<158>)
.PROBE TRAN
+    V(multiplicand<159>)
+    V(multiplicand<160>)
+    V(multiplicand<161>)
+    V(multiplicand<162>)
+    V(multiplicand<163>)
+    V(multiplicand<164>)
+    V(multiplicand<165>)
+    V(multiplicand<166>)
+    V(multiplicand<167>)
+    V(multiplicand<168>)
+    V(multiplicand<169>)
+    V(multiplicand<170>)
+    V(multiplicand<171>)
+    V(multiplicand<172>)
+    V(multiplicand<173>)
+    V(multiplicand<174>)
+    V(multiplicand<175>)
+    V(multiplicand<176>)
+    V(multiplicand<177>)
+    V(multiplicand<178>)
+    V(multiplicand<179>)
+    V(multiplicand<180>)
+    V(multiplicand<181>)
+    V(multiplicand<182>)
+    V(multiplicand<183>)
+    V(multiplicand<184>)
+    V(multiplicand<185>)
+    V(multiplicand<186>)
+    V(multiplicand<187>)
+    V(multiplicand<188>)
+    V(multiplicand<189>)
+    V(multiplicand<190>)
.PROBE TRAN
+    V(multiplicand<191>)
+    V(multiplicand<192>)
+    V(multiplicand<193>)
+    V(multiplicand<194>)
+    V(multiplicand<195>)
+    V(multiplicand<196>)
+    V(multiplicand<197>)
+    V(multiplicand<198>)
+    V(multiplicand<199>)
+    V(multiplicand<200>)
+    V(multiplicand<201>)
+    V(multiplicand<202>)
+    V(multiplicand<203>)
+    V(multiplicand<204>)
+    V(multiplicand<205>)
+    V(multiplicand<206>)
+    V(multiplicand<207>)
+    V(multiplicand<208>)
+    V(multiplicand<209>)
+    V(multiplicand<210>)
+    V(multiplicand<211>)
+    V(multiplicand<212>)
+    V(multiplicand<213>)
+    V(multiplicand<214>)
+    V(multiplicand<215>)
+    V(multiplicand<216>)
+    V(multiplicand<217>)
+    V(multiplicand<218>)
+    V(multiplicand<219>)
+    V(multiplicand<220>)
+    V(multiplicand<221>)
+    V(multiplicand<222>)
.PROBE TRAN
+    V(multiplicand<223>)
+    V(multiplicand<224>)
+    V(multiplicand<225>)
+    V(multiplicand<226>)
+    V(multiplicand<227>)
+    V(multiplicand<228>)
+    V(multiplicand<229>)
+    V(multiplicand<230>)
+    V(multiplicand<231>)
+    V(multiplicand<232>)
+    V(multiplicand<233>)
+    V(multiplicand<234>)
+    V(multiplicand<235>)
+    V(multiplicand<236>)
+    V(multiplicand<237>)
+    V(multiplicand<238>)
+    V(multiplicand<239>)
+    V(multiplicand<240>)
+    V(multiplicand<241>)
+    V(multiplicand<242>)
+    V(multiplicand<243>)
+    V(multiplicand<244>)
+    V(multiplicand<245>)
+    V(multiplicand<246>)
+    V(multiplicand<247>)
+    V(multiplicand<248>)
+    V(multiplicand<249>)
+    V(multiplicand<250>)
+    V(multiplicand<251>)
+    V(multiplicand<252>)
+    V(multiplicand<253>)
+    V(multiplicand<254>)
.PROBE TRAN
+    V(multiplicand<255>)
+    V(result<0>)
+    V(result<1>)
+    V(result<2>)
+    V(result<3>)
+    V(result<4>)
+    V(result<5>)
+    V(result<6>)
+    V(result<7>)
+    V(result<8>)
+    V(result<9>)
+    V(result<10>)
+    V(result<11>)
+    V(clk)
