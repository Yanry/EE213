** Copy your MAC netlist (.subckt) here
** Design view name: schematic
.GLOBAL vdd!

** Library name: MyLibPDK45
** Cell name: myMAC_64_3bit_4bit
** View name: schematic
.subckt MAC_64 multiplicand<255> multiplicand<254> multiplicand<253> multiplicand<252> multiplicand<251> multiplicand<250> multiplicand<249> multiplicand<248> multiplicand<247> multiplicand<246> multiplicand<245> multiplicand<244> multiplicand<243> multiplicand<242> multiplicand<241> multiplicand<240> multiplicand<239> multiplicand<238> multiplicand<237> multiplicand<236> multiplicand<235> multiplicand<234> multiplicand<233> multiplicand<232> multiplicand<231> multiplicand<230> multiplicand<229> multiplicand<228> multiplicand<227> multiplicand<226> multiplicand<225> multiplicand<224> multiplicand<223> multiplicand<222> multiplicand<221> multiplicand<220> multiplicand<219> multiplicand<218> multiplicand<217> multiplicand<216> multiplicand<215> multiplicand<214> multiplicand<213> multiplicand<212> multiplicand<211> multiplicand<210> multiplicand<209> multiplicand<208> multiplicand<207> multiplicand<206> multiplicand<205> multiplicand<204> multiplicand<203> multiplicand<202> multiplicand<201> multiplicand<200>
+multiplicand<199> multiplicand<198> multiplicand<197> multiplicand<196> multiplicand<195> multiplicand<194> multiplicand<193> multiplicand<192> multiplicand<191> multiplicand<190> multiplicand<189> multiplicand<188> multiplicand<187> multiplicand<186> multiplicand<185> multiplicand<184> multiplicand<183> multiplicand<182> multiplicand<181> multiplicand<180> multiplicand<179> multiplicand<178> multiplicand<177> multiplicand<176> multiplicand<175> multiplicand<174> multiplicand<173> multiplicand<172> multiplicand<171> multiplicand<170> multiplicand<169> multiplicand<168> multiplicand<167> multiplicand<166> multiplicand<165> multiplicand<164> multiplicand<163> multiplicand<162> multiplicand<161> multiplicand<160> multiplicand<159> multiplicand<158> multiplicand<157> multiplicand<156> multiplicand<155> multiplicand<154> multiplicand<153> multiplicand<152> multiplicand<151> multiplicand<150> multiplicand<149> multiplicand<148> multiplicand<147> multiplicand<146> multiplicand<145> multiplicand<144>
+multiplicand<143> multiplicand<142> multiplicand<141> multiplicand<140> multiplicand<139> multiplicand<138> multiplicand<137> multiplicand<136> multiplicand<135> multiplicand<134> multiplicand<133> multiplicand<132> multiplicand<131> multiplicand<130> multiplicand<129> multiplicand<128> multiplicand<127> multiplicand<126> multiplicand<125> multiplicand<124> multiplicand<123> multiplicand<122> multiplicand<121> multiplicand<120> multiplicand<119> multiplicand<118> multiplicand<117> multiplicand<116> multiplicand<115> multiplicand<114> multiplicand<113> multiplicand<112> multiplicand<111> multiplicand<110> multiplicand<109> multiplicand<108> multiplicand<107> multiplicand<106> multiplicand<105> multiplicand<104> multiplicand<103> multiplicand<102> multiplicand<101> multiplicand<100> multiplicand<99> multiplicand<98> multiplicand<97> multiplicand<96> multiplicand<95> multiplicand<94> multiplicand<93> multiplicand<92> multiplicand<91> multiplicand<90> multiplicand<89> multiplicand<88> multiplicand<87>
+multiplicand<86> multiplicand<85> multiplicand<84> multiplicand<83> multiplicand<82> multiplicand<81> multiplicand<80> multiplicand<79> multiplicand<78> multiplicand<77> multiplicand<76> multiplicand<75> multiplicand<74> multiplicand<73> multiplicand<72> multiplicand<71> multiplicand<70> multiplicand<69> multiplicand<68> multiplicand<67> multiplicand<66> multiplicand<65> multiplicand<64> multiplicand<63> multiplicand<62> multiplicand<61> multiplicand<60> multiplicand<59> multiplicand<58> multiplicand<57> multiplicand<56> multiplicand<55> multiplicand<54> multiplicand<53> multiplicand<52> multiplicand<51> multiplicand<50> multiplicand<49> multiplicand<48> multiplicand<47> multiplicand<46> multiplicand<45> multiplicand<44> multiplicand<43> multiplicand<42> multiplicand<41> multiplicand<40> multiplicand<39> multiplicand<38> multiplicand<37> multiplicand<36> multiplicand<35> multiplicand<34> multiplicand<33> multiplicand<32> multiplicand<31> multiplicand<30> multiplicand<29> multiplicand<28> multiplicand<27>
+multiplicand<26> multiplicand<25> multiplicand<24> multiplicand<23> multiplicand<22> multiplicand<21> multiplicand<20> multiplicand<19> multiplicand<18> multiplicand<17> multiplicand<16> multiplicand<15> multiplicand<14> multiplicand<13> multiplicand<12> multiplicand<11> multiplicand<10> multiplicand<9> multiplicand<8> multiplicand<7> multiplicand<6> multiplicand<5> multiplicand<4> multiplicand<3> multiplicand<2> multiplicand<1> multiplicand<0> multiplier<191> multiplier<190> multiplier<189> multiplier<188> multiplier<187> multiplier<186> multiplier<185> multiplier<184> multiplier<183> multiplier<182> multiplier<181> multiplier<180> multiplier<179> multiplier<178> multiplier<177> multiplier<176> multiplier<175> multiplier<174> multiplier<173> multiplier<172> multiplier<171> multiplier<170> multiplier<169> multiplier<168> multiplier<167> multiplier<166> multiplier<165> multiplier<164> multiplier<163> multiplier<162> multiplier<161> multiplier<160> multiplier<159> multiplier<158> multiplier<157>
+multiplier<156> multiplier<155> multiplier<154> multiplier<153> multiplier<152> multiplier<151> multiplier<150> multiplier<149> multiplier<148> multiplier<147> multiplier<146> multiplier<145> multiplier<144> multiplier<143> multiplier<142> multiplier<141> multiplier<140> multiplier<139> multiplier<138> multiplier<137> multiplier<136> multiplier<135> multiplier<134> multiplier<133> multiplier<132> multiplier<131> multiplier<130> multiplier<129> multiplier<128> multiplier<127> multiplier<126> multiplier<125> multiplier<124> multiplier<123> multiplier<122> multiplier<121> multiplier<120> multiplier<119> multiplier<118> multiplier<117> multiplier<116> multiplier<115> multiplier<114> multiplier<113> multiplier<112> multiplier<111> multiplier<110> multiplier<109> multiplier<108> multiplier<107> multiplier<106> multiplier<105> multiplier<104> multiplier<103> multiplier<102> multiplier<101> multiplier<100> multiplier<99> multiplier<98> multiplier<97> multiplier<96> multiplier<95> multiplier<94> multiplier<93>
+multiplier<92> multiplier<91> multiplier<90> multiplier<89> multiplier<88> multiplier<87> multiplier<86> multiplier<85> multiplier<84> multiplier<83> multiplier<82> multiplier<81> multiplier<80> multiplier<79> multiplier<78> multiplier<77> multiplier<76> multiplier<75> multiplier<74> multiplier<73> multiplier<72> multiplier<71> multiplier<70> multiplier<69> multiplier<68> multiplier<67> multiplier<66> multiplier<65> multiplier<64> multiplier<63> multiplier<62> multiplier<61> multiplier<60> multiplier<59> multiplier<58> multiplier<57> multiplier<56> multiplier<55> multiplier<54> multiplier<53> multiplier<52> multiplier<51> multiplier<50> multiplier<49> multiplier<48> multiplier<47> multiplier<46> multiplier<45> multiplier<44> multiplier<43> multiplier<42> multiplier<41> multiplier<40> multiplier<39> multiplier<38> multiplier<37> multiplier<36> multiplier<35> multiplier<34> multiplier<33> multiplier<32> multiplier<31> multiplier<30> multiplier<29> multiplier<28> multiplier<27> multiplier<26> multiplier<25>
+multiplier<24> multiplier<23> multiplier<22> multiplier<21> multiplier<20> multiplier<19> multiplier<18> multiplier<17> multiplier<16> multiplier<15> multiplier<14> multiplier<13> multiplier<12> multiplier<11> multiplier<10> multiplier<9> multiplier<8> multiplier<7> multiplier<6> multiplier<5> multiplier<4> multiplier<3> multiplier<2> multiplier<1> multiplier<0> result<11> result<10> result<9> result<8> result<7> result<6> result<5> result<4> result<3> result<2> result<1> result<0>

** Library name: MyLibPDK45
** Cell name: myInverter45
** View name: schematic
.subckt myInverter45 in out
m0 out in 0 0 NMOS_VTL L=50e-9 W=90e-9 AD=9.45e-15 AS=9.45e-15 PD=300e-9 PS=300e-9 M=1
m1 out in vdd! vdd! PMOS_VTL L=50e-9 W=180e-9 AD=9.45e-15 AS=9.45e-15 PD=300e-9 PS=300e-9 M=1
.ends myInverter45
** End of subcircuit definition.

** Library name: MyLibPDK45
** Cell name: myFA
** View name: schematic
.subckt myFA a b cin cout s
m11 net35 cin net068 vdd! PMOS_VTL L=50e-9 W=180e-9 AD=9.45e-15 AS=9.45e-15 PD=300e-9 PS=300e-9 M=1
m10 net068 a net069 vdd! PMOS_VTL L=50e-9 W=180e-9 AD=9.45e-15 AS=9.45e-15 PD=300e-9 PS=300e-9 M=1
m9 net069 b vdd! vdd! PMOS_VTL L=50e-9 W=180e-9 AD=9.45e-15 AS=9.45e-15 PD=300e-9 PS=300e-9 M=1
m8 net35 net79 net42 vdd! PMOS_VTL L=50e-9 W=180e-9 AD=9.45e-15 AS=9.45e-15 PD=300e-9 PS=300e-9 M=1
m7 net42 cin vdd! vdd! PMOS_VTL L=50e-9 W=180e-9 AD=9.45e-15 AS=9.45e-15 PD=300e-9 PS=300e-9 M=1
m6 net42 b vdd! vdd! PMOS_VTL L=50e-9 W=180e-9 AD=9.45e-15 AS=9.45e-15 PD=300e-9 PS=300e-9 M=1
m5 net42 a vdd! vdd! PMOS_VTL L=50e-9 W=180e-9 AD=9.45e-15 AS=9.45e-15 PD=300e-9 PS=300e-9 M=1
m4 net79 a net071 vdd! PMOS_VTL L=50e-9 W=180e-9 AD=9.45e-15 AS=9.45e-15 PD=300e-9 PS=300e-9 M=1
m3 net071 b vdd! vdd! PMOS_VTL L=50e-9 W=180e-9 AD=9.45e-15 AS=9.45e-15 PD=300e-9 PS=300e-9 M=1
m2 net79 cin net7 vdd! PMOS_VTL L=50e-9 W=180e-9 AD=9.45e-15 AS=9.45e-15 PD=300e-9 PS=300e-9 M=1
m1 net7 b vdd! vdd! PMOS_VTL L=50e-9 W=180e-9 AD=9.45e-15 AS=9.45e-15 PD=300e-9 PS=300e-9 M=1
m0 net7 a vdd! vdd! PMOS_VTL L=50e-9 W=180e-9 AD=9.45e-15 AS=9.45e-15 PD=300e-9 PS=300e-9 M=1
m23 net60 b 0 0 NMOS_VTL L=50e-9 W=90e-9 AD=9.45e-15 AS=9.45e-15 PD=300e-9 PS=300e-9 M=1
m22 net64 a net60 0 NMOS_VTL L=50e-9 W=90e-9 AD=9.45e-15 AS=9.45e-15 PD=300e-9 PS=300e-9 M=1
m21 net35 cin net64 0 NMOS_VTL L=50e-9 W=90e-9 AD=9.45e-15 AS=9.45e-15 PD=300e-9 PS=300e-9 M=1
m20 net65 cin 0 0 NMOS_VTL L=50e-9 W=90e-9 AD=9.45e-15 AS=9.45e-15 PD=300e-9 PS=300e-9 M=1
m19 net65 b 0 0 NMOS_VTL L=50e-9 W=90e-9 AD=9.45e-15 AS=9.45e-15 PD=300e-9 PS=300e-9 M=1
m18 net65 a 0 0 NMOS_VTL L=50e-9 W=90e-9 AD=9.45e-15 AS=9.45e-15 PD=300e-9 PS=300e-9 M=1
m17 net35 net79 net65 0 NMOS_VTL L=50e-9 W=90e-9 AD=9.45e-15 AS=9.45e-15 PD=300e-9 PS=300e-9 M=1
m16 net12 b 0 0 NMOS_VTL L=50e-9 W=90e-9 AD=9.45e-15 AS=9.45e-15 PD=300e-9 PS=300e-9 M=1
m15 net79 a net12 0 NMOS_VTL L=50e-9 W=90e-9 AD=9.45e-15 AS=9.45e-15 PD=300e-9 PS=300e-9 M=1
m14 net4 b 0 0 NMOS_VTL L=50e-9 W=90e-9 AD=9.45e-15 AS=9.45e-15 PD=300e-9 PS=300e-9 M=1
m13 net4 a 0 0 NMOS_VTL L=50e-9 W=90e-9 AD=9.45e-15 AS=9.45e-15 PD=300e-9 PS=300e-9 M=1
m12 net79 cin net4 0 NMOS_VTL L=50e-9 W=90e-9 AD=9.45e-15 AS=9.45e-15 PD=300e-9 PS=300e-9 M=1
xi10 net35 s myInverter45
xi9 net79 cout myInverter45
.ends myFA
** End of subcircuit definition.

** Library name: MyLibPDK45
** Cell name: myAdder_6bit
** View name: schematic
.subckt myAdder_6bit a<5> a<4> a<3> a<2> a<1> a<0> b<5> b<4> b<3> b<2> b<1> b<0> cin s<6> s<5> s<4> s<3> s<2> s<1> s<0>
xi11 net013 a<5> b<5> net025 s<6> myFA
xi10 net15 a<5> b<5> net013 s<5> myFA
xi9 net17 a<4> b<4> net15 s<4> myFA
xi8 net19 a<3> b<3> net17 s<3> myFA
xi7 net21 a<2> b<2> net19 s<2> myFA
xi6 net23 a<1> b<1> net21 s<1> myFA
xi0 cin a<0> b<0> net23 s<0> myFA
.ends myAdder_6bit
** End of subcircuit definition.

** Library name: MyLibPDK45
** Cell name: myAdder_7bit
** View name: schematic
.subckt myAdder_7bit a<6> a<5> a<4> a<3> a<2> a<1> a<0> b<6> b<5> b<4> b<3> b<2> b<1> b<0> cin s<7> s<6> s<5> s<4> s<3> s<2> s<1> s<0>
xi0 a<6> a<5> a<4> a<3> a<2> a<1> b<6> b<5> b<4> b<3> b<2> b<1> net7 s<7> s<6> s<5> s<4> s<3> s<2> s<1> myAdder_6bit
xi1 cin a<0> b<0> net7 s<0> myFA
.ends myAdder_7bit
** End of subcircuit definition.

** Library name: MyLibPDK45
** Cell name: myAdder_8bit
** View name: schematic
.subckt myAdder_8bit a<7> a<6> a<5> a<4> a<3> a<2> a<1> a<0> b<7> b<6> b<5> b<4> b<3> b<2> b<1> b<0> cin s<8> s<7> s<6> s<5> s<4> s<3> s<2> s<1> s<0>
xi1 cin a<0> b<0> net7 s<0> myFA
xi0 a<7> a<6> a<5> a<4> a<3> a<2> a<1> b<7> b<6> b<5> b<4> b<3> b<2> b<1> net7 s<8> s<7> s<6> s<5> s<4> s<3> s<2> s<1> myAdder_7bit
.ends myAdder_8bit
** End of subcircuit definition.

** Library name: MyLibPDK45
** Cell name: myAdder_9bit
** View name: schematic
.subckt myAdder_9bit a<6> a<5> a<4> a<3> a<2> a<1> a<0> b<6> b<5> b<4> b<3> b<2> b<1> b<0> cin s<7> s<6> s<5> s<4> s<3> s<2> s<1> s<0> a<8> a<7> b<8> b<7> s<9> s<8>
xi0 a<8> a<7> a<6> a<5> a<4> a<3> a<2> a<1> b<8> b<7> b<6> b<5> b<4> b<3> b<2> b<1> net7 s<9> s<8> s<7> s<6> s<5> s<4> s<3> s<2> s<1> myAdder_8bit
xi1 cin a<0> b<0> net7 s<0> myFA
.ends myAdder_9bit
** End of subcircuit definition.

** Library name: MyLibPDK45
** Cell name: myAdder_10bit
** View name: schematic
.subckt myAdder_10bit a<6> a<5> a<4> a<3> a<2> a<1> a<0> b<6> b<5> b<4> b<3> b<2> b<1> b<0> cin s<7> s<6> s<5> s<4> s<3> s<2> s<1> s<0> a<9> a<8> a<7> b<9> b<8> b<7> s<10> s<9> s<8>
xi1 cin a<0> b<0> net7 s<0> myFA
xi0 a<7> a<6> a<5> a<4> a<3> a<2> a<1> b<7> b<6> b<5> b<4> b<3> b<2> b<1> net7 s<8> s<7> s<6> s<5> s<4> s<3> s<2> s<1> a<9> a<8> b<9> b<8> s<10> s<9> myAdder_9bit
.ends myAdder_10bit
** End of subcircuit definition.

** Library name: MyLibPDK45
** Cell name: myAdder_11bit
** View name: schematic
.subckt myAdder_11bit a<6> a<5> a<4> a<3> a<2> a<1> a<0> b<6> b<5> b<4> b<3> b<2> b<1> b<0> cin s<7> s<6> s<5> s<4> s<3> s<2> s<1> s<0> a<10> a<9> a<8> a<7> b<10> b<9> b<8> b<7> s<11> s<10> s<9> s<8>
xi0 a<7> a<6> a<5> a<4> a<3> a<2> a<1> b<7> b<6> b<5> b<4> b<3> b<2> b<1> net7 s<8> s<7> s<6> s<5> s<4> s<3> s<2> s<1> a<10> a<9> a<8> b<10> b<9> b<8> s<11> s<10> s<9> myAdder_10bit
xi1 cin a<0> b<0> net7 s<0> myFA
.ends myAdder_11bit
** End of subcircuit definition.

** Library name: MyLibPDK45
** Cell name: myBuffer_2
** View name: schematic
.subckt myBuffer_2 in out
xi1 net5 out myInverter45
xi0 in net5 myInverter45
.ends myBuffer_2
** End of subcircuit definition.

** Library name: MyLibPDK45
** Cell name: myNAND
** View name: schematic
.subckt myNAND a b z
m1 z b net013 0 NMOS_VTL L=50e-9 W=90e-9 AD=9.45e-15 AS=9.45e-15 PD=300e-9 PS=300e-9 M=1
m0 net013 a 0 0 NMOS_VTL L=50e-9 W=90e-9 AD=9.45e-15 AS=9.45e-15 PD=300e-9 PS=300e-9 M=1
m3 z a vdd! vdd! PMOS_VTL L=50e-9 W=180e-9 AD=9.45e-15 AS=9.45e-15 PD=300e-9 PS=300e-9 M=1
m2 z b vdd! vdd! PMOS_VTL L=50e-9 W=180e-9 AD=9.45e-15 AS=9.45e-15 PD=300e-9 PS=300e-9 M=1
.ends myNAND
** End of subcircuit definition.

** Library name: MyLibPDK45
** Cell name: myXOR
** View name: schematic
.subckt myXOR a b z
m1 a bbar z 0 NMOS_VTL L=50e-9 W=90e-9 AD=9.45e-15 AS=9.45e-15 PD=300e-9 PS=300e-9 M=1
m0 z a bbar 0 NMOS_VTL L=50e-9 W=90e-9 AD=9.45e-15 AS=9.45e-15 PD=300e-9 PS=300e-9 M=1
m3 a b z vdd! PMOS_VTL L=50e-9 W=180e-9 AD=9.45e-15 AS=9.45e-15 PD=300e-9 PS=300e-9 M=1
m2 z a b vdd! PMOS_VTL L=50e-9 W=180e-9 AD=9.45e-15 AS=9.45e-15 PD=300e-9 PS=300e-9 M=1
xi0 b bbar myInverter45
.ends myXOR
** End of subcircuit definition.

** Library name: MyLibPDK45
** Cell name: myHA
** View name: schematic
.subckt myHA a b cout s
xi0 a b net11 myNAND
xi1 net11 cout myInverter45
xi2 a b s myXOR
.ends myHA
** End of subcircuit definition.

** Library name: MyLibPDK45
** Cell name: myPPA_4_3
** View name: schematic
.subckt myPPA_4_3 a0<3> a0<2> a0<1> a0<0> a1<3> a1<2> a1<1> a1<0> a2<3> a2<2> a2<1> a2<0> s<5> s<4> s<3> s<2> s<1> s<0>
xi16 vdd! net025 net016 s<2> myHA
xi21 net012 net021 net010 s<4> myHA
xi22 net010 net020 net032 s<5> myHA
xi6 a2bar<0> net34 net1 net025 myHA
xi5 net28 a1bar<3> net5 net6 myHA
xi0 a0<1> a1<0> net35 s<1> myHA
xi18 net016 vdd! net023 net012 s<3> myFA
xi9 net18 a2<3> net5 net027 net020 myFA
xi8 net20 a2bar<2> net6 net18 net021 myFA
xi7 net1 a2bar<1> net29 net20 net023 myFA
xi4 net33 a0bar<3> a1<2> net28 net29 myFA
xi3 net35 a0<2> a1<1> net33 net34 myFA
xi10 a0<0> s<0> myBuffer_2
xi11 a1<3> a1bar<3> myInverter45
xi12 a0<3> a0bar<3> myInverter45
xi13 a2<2> a2bar<2> myInverter45
xi14 a2<1> a2bar<1> myInverter45
xi15 a2<0> a2bar<0> myInverter45
.ends myPPA_4_3
** End of subcircuit definition.

** Library name: MyLibPDK45
** Cell name: myAnd
** View name: schematic
.subckt myAnd a b z
xi0 a b net7 myNAND
xi1 net7 z myInverter45
.ends myAnd
** End of subcircuit definition.

** Library name: MyLibPDK45
** Cell name: myMulti_3bit_4bit
** View name: schematic
.subckt myMulti_3bit_4bit multiplicand<3> multiplicand<2> multiplicand<1> multiplicand<0> multiplier<2> multiplier<1> multiplier<0> s<5> s<4> s<3> s<2> s<1> s<0>
xi0 a0<3> a0<2> a0<1> a0<0> a1<3> a1<2> a1<1> a1<0> a2<3> a2<2> a2<1> a2<0> s<5> s<4> s<3> s<2> s<1> s<0> myPPA_4_3
xi12 multiplicand<0> multiplier<2> a2<0> myAnd
xi11 multiplicand<1> multiplier<2> a2<1> myAnd
xi10 multiplicand<2> multiplier<2> a2<2> myAnd
xi9 multiplicand<3> multiplier<2> a2<3> myAnd
xi8 multiplicand<0> multiplier<1> a1<0> myAnd
xi7 multiplicand<1> multiplier<1> a1<1> myAnd
xi6 multiplicand<2> multiplier<1> a1<2> myAnd
xi5 multiplicand<3> multiplier<1> a1<3> myAnd
xi4 multiplicand<3> multiplier<0> a0<3> myAnd
xi3 multiplicand<2> multiplier<0> a0<2> myAnd
xi2 multiplicand<1> multiplier<0> a0<1> myAnd
xi1 multiplicand<0> multiplier<0> a0<0> myAnd
.ends myMulti_3bit_4bit
** End of subcircuit definition.

** Library name: MyLibPDK45
** Cell name: myMAC_2_3bit_4bit
** View name: schematic
.subckt myMAC_2_3bit_4bit multiplicand<7> multiplicand<6> multiplicand<5> multiplicand<4> multiplicand<3> multiplicand<2> multiplicand<1> multiplicand<0> multiplier<5> multiplier<4> multiplier<3> multiplier<2> multiplier<1> multiplier<0> result<6> result<5> result<4> result<3> result<2> result<1> result<0>
xi1 multiplicand<7> multiplicand<6> multiplicand<5> multiplicand<4> multiplier<5> multiplier<4> multiplier<3> net6<0> net6<1> net6<2> net6<3> net6<4> net6<5> myMulti_3bit_4bit
xi0 multiplicand<3> multiplicand<2> multiplicand<1> multiplicand<0> multiplier<2> multiplier<1> multiplier<0> net7<0> net7<1> net7<2> net7<3> net7<4> net7<5> myMulti_3bit_4bit
xi4 net7<0> net7<1> net7<2> net7<3> net7<4> net7<5> net6<0> net6<1> net6<2> net6<3> net6<4> net6<5> 0 result<6> result<5> result<4> result<3> result<2> result<1> result<0> myAdder_6bit
.ends myMAC_2_3bit_4bit
** End of subcircuit definition.

** Library name: MyLibPDK45
** Cell name: myMAC_4_3bit_4bit
** View name: schematic
.subckt myMAC_4_3bit_4bit multiplicand<15> multiplicand<14> multiplicand<13> multiplicand<12> multiplicand<11> multiplicand<10> multiplicand<9> multiplicand<8> multiplicand<7> multiplicand<6> multiplicand<5> multiplicand<4> multiplicand<3> multiplicand<2> multiplicand<1> multiplicand<0> multiplier<11> multiplier<10> multiplier<9> multiplier<8> multiplier<7> multiplier<6> multiplier<5> multiplier<4> multiplier<3> multiplier<2> multiplier<1> multiplier<0> result<7> result<6> result<5> result<4> result<3> result<2> result<1> result<0>
xi1 multiplicand<15> multiplicand<14> multiplicand<13> multiplicand<12> multiplicand<11> multiplicand<10> multiplicand<9> multiplicand<8> multiplier<11> multiplier<10> multiplier<9> multiplier<8> multiplier<7> multiplier<6> net9<0> net9<1> net9<2> net9<3> net9<4> net9<5> net9<6> myMAC_2_3bit_4bit
xi0 multiplicand<7> multiplicand<6> multiplicand<5> multiplicand<4> multiplicand<3> multiplicand<2> multiplicand<1> multiplicand<0> multiplier<5> multiplier<4> multiplier<3> multiplier<2> multiplier<1> multiplier<0> net10<0> net10<1> net10<2> net10<3> net10<4> net10<5> net10<6> myMAC_2_3bit_4bit
xi2 net10<0> net10<1> net10<2> net10<3> net10<4> net10<5> net10<6> net9<0> net9<1> net9<2> net9<3> net9<4> net9<5> net9<6> 0 result<7> result<6> result<5> result<4> result<3> result<2> result<1> result<0> myAdder_7bit
.ends myMAC_4_3bit_4bit
** End of subcircuit definition.

** Library name: MyLibPDK45
** Cell name: myMAC_8_3bit_4bit
** View name: schematic
.subckt myMAC_8_3bit_4bit multiplicand<31> multiplicand<30> multiplicand<29> multiplicand<28> multiplicand<27> multiplicand<26> multiplicand<25> multiplicand<24> multiplicand<23> multiplicand<22> multiplicand<21> multiplicand<20> multiplicand<19> multiplicand<18> multiplicand<17> multiplicand<16> multiplicand<15> multiplicand<14> multiplicand<13> multiplicand<12> multiplicand<11> multiplicand<10> multiplicand<9> multiplicand<8> multiplicand<7> multiplicand<6> multiplicand<5> multiplicand<4> multiplicand<3> multiplicand<2> multiplicand<1> multiplicand<0> multiplier<23> multiplier<22> multiplier<21> multiplier<20> multiplier<19> multiplier<18> multiplier<17> multiplier<16> multiplier<15> multiplier<14> multiplier<13> multiplier<12> multiplier<11> multiplier<10> multiplier<9> multiplier<8> multiplier<7> multiplier<6> multiplier<5> multiplier<4> multiplier<3> multiplier<2> multiplier<1> multiplier<0> result<8> result<7> result<6> result<5> result<4> result<3> result<2> result<1> result<0>
xi2 net010<0> net010<1> net010<2> net010<3> net010<4> net010<5> net010<6> net010<7> net09<0> net09<1> net09<2> net09<3> net09<4> net09<5> net09<6> net09<7> 0 result<8> result<7> result<6> result<5> result<4> result<3> result<2> result<1> result<0> myAdder_8bit
xi1 multiplicand<31> multiplicand<30> multiplicand<29> multiplicand<28> multiplicand<27> multiplicand<26> multiplicand<25> multiplicand<24> multiplicand<23> multiplicand<22> multiplicand<21> multiplicand<20> multiplicand<19> multiplicand<18> multiplicand<17> multiplicand<16> multiplier<23> multiplier<22> multiplier<21> multiplier<20> multiplier<19> multiplier<18> multiplier<17> multiplier<16> multiplier<15> multiplier<14> multiplier<13> multiplier<12> net09<0> net09<1> net09<2> net09<3> net09<4> net09<5> net09<6> net09<7> myMAC_4_3bit_4bit
xi0 multiplicand<15> multiplicand<14> multiplicand<13> multiplicand<12> multiplicand<11> multiplicand<10> multiplicand<9> multiplicand<8> multiplicand<7> multiplicand<6> multiplicand<5> multiplicand<4> multiplicand<3> multiplicand<2> multiplicand<1> multiplicand<0> multiplier<11> multiplier<10> multiplier<9> multiplier<8> multiplier<7> multiplier<6> multiplier<5> multiplier<4> multiplier<3> multiplier<2> multiplier<1> multiplier<0> net010<0> net010<1> net010<2> net010<3> net010<4> net010<5> net010<6> net010<7> myMAC_4_3bit_4bit
.ends myMAC_8_3bit_4bit
** End of subcircuit definition.

** Library name: MyLibPDK45
** Cell name: myMAC_16_3bit_4bit
** View name: schematic
.subckt myMAC_16_3bit_4bit multiplicand<15> multiplicand<14> multiplicand<13> multiplicand<12> multiplicand<11> multiplicand<10> multiplicand<9> multiplicand<8> multiplicand<7> multiplicand<6> multiplicand<5> multiplicand<4> multiplicand<3> multiplicand<2> multiplicand<1> multiplicand<0> multiplier<11> multiplier<10> multiplier<9> multiplier<8> multiplier<7> multiplier<6> multiplier<5> multiplier<4> multiplier<3> multiplier<2> multiplier<1> multiplier<0> result<7> result<6> result<5> result<4> result<3> result<2> result<1> result<0> multiplicand<63> multiplicand<62> multiplicand<61> multiplicand<60> multiplicand<59> multiplicand<58> multiplicand<57> multiplicand<56> multiplicand<55> multiplicand<54> multiplicand<53> multiplicand<52> multiplicand<51> multiplicand<50> multiplicand<49> multiplicand<48> multiplicand<47> multiplicand<46> multiplicand<45> multiplicand<44> multiplicand<43> multiplicand<42> multiplicand<41> multiplicand<40> multiplicand<39> multiplicand<38> multiplicand<37> multiplicand<36>
+multiplicand<35> multiplicand<34> multiplicand<33> multiplicand<32> multiplicand<31> multiplicand<30> multiplicand<29> multiplicand<28> multiplicand<27> multiplicand<26> multiplicand<25> multiplicand<24> multiplicand<23> multiplicand<22> multiplicand<21> multiplicand<20> multiplicand<19> multiplicand<18> multiplicand<17> multiplicand<16> multiplier<47> multiplier<46> multiplier<45> multiplier<44> multiplier<43> multiplier<42> multiplier<41> multiplier<40> multiplier<39> multiplier<38> multiplier<37> multiplier<36> multiplier<35> multiplier<34> multiplier<33> multiplier<32> multiplier<31> multiplier<30> multiplier<29> multiplier<28> multiplier<27> multiplier<26> multiplier<25> multiplier<24> multiplier<23> multiplier<22> multiplier<21> multiplier<20> multiplier<19> multiplier<18> multiplier<17> multiplier<16> multiplier<15> multiplier<14> multiplier<13> multiplier<12> result<9> result<8>
xi1 multiplicand<63> multiplicand<62> multiplicand<61> multiplicand<60> multiplicand<59> multiplicand<58> multiplicand<57> multiplicand<56> multiplicand<55> multiplicand<54> multiplicand<53> multiplicand<52> multiplicand<51> multiplicand<50> multiplicand<49> multiplicand<48> multiplicand<47> multiplicand<46> multiplicand<45> multiplicand<44> multiplicand<43> multiplicand<42> multiplicand<41> multiplicand<40> multiplicand<39> multiplicand<38> multiplicand<37> multiplicand<36> multiplicand<35> multiplicand<34> multiplicand<33> multiplicand<32> multiplier<47> multiplier<46> multiplier<45> multiplier<44> multiplier<43> multiplier<42> multiplier<41> multiplier<40> multiplier<39> multiplier<38> multiplier<37> multiplier<36> multiplier<35> multiplier<34> multiplier<33> multiplier<32> multiplier<31> multiplier<30> multiplier<29> multiplier<28> multiplier<27> multiplier<26> multiplier<25> multiplier<24> net09<0> net09<1> net09<2> net09<3> net09<4> net09<5> net09<6> net09<7> net09<8> myMAC_8_3bit_4bit
xi0 multiplicand<31> multiplicand<30> multiplicand<29> multiplicand<28> multiplicand<27> multiplicand<26> multiplicand<25> multiplicand<24> multiplicand<23> multiplicand<22> multiplicand<21> multiplicand<20> multiplicand<19> multiplicand<18> multiplicand<17> multiplicand<16> multiplicand<15> multiplicand<14> multiplicand<13> multiplicand<12> multiplicand<11> multiplicand<10> multiplicand<9> multiplicand<8> multiplicand<7> multiplicand<6> multiplicand<5> multiplicand<4> multiplicand<3> multiplicand<2> multiplicand<1> multiplicand<0> multiplier<23> multiplier<22> multiplier<21> multiplier<20> multiplier<19> multiplier<18> multiplier<17> multiplier<16> multiplier<15> multiplier<14> multiplier<13> multiplier<12> multiplier<11> multiplier<10> multiplier<9> multiplier<8> multiplier<7> multiplier<6> multiplier<5> multiplier<4> multiplier<3> multiplier<2> multiplier<1> multiplier<0> net010<0> net010<1> net010<2> net010<3> net010<4> net010<5> net010<6> net010<7> net010<8> myMAC_8_3bit_4bit
xi2 net010<2> net010<3> net010<4> net010<5> net010<6> net010<7> net010<8> net09<2> net09<3> net09<4> net09<5> net09<6> net09<7> net09<8> 0 result<7> result<6> result<5> result<4> result<3> result<2> result<1> result<0> net010<0> net010<1> net09<0> net09<1> result<9> result<8> myAdder_9bit
.ends myMAC_16_3bit_4bit
** End of subcircuit definition.

** Library name: MyLibPDK45
** Cell name: myMAC_32_3bit_4bit
** View name: schematic
.subckt myMAC_32_3bit_4bit multiplicand<15> multiplicand<14> multiplicand<13> multiplicand<12> multiplicand<11> multiplicand<10> multiplicand<9> multiplicand<8> multiplicand<7> multiplicand<6> multiplicand<5> multiplicand<4> multiplicand<3> multiplicand<2> multiplicand<1> multiplicand<0> multiplier<11> multiplier<10> multiplier<9> multiplier<8> multiplier<7> multiplier<6> multiplier<5> multiplier<4> multiplier<3> multiplier<2> multiplier<1> multiplier<0> result<7> result<6> result<5> result<4> result<3> result<2> result<1> result<0> multiplicand<127> multiplicand<126> multiplicand<125> multiplicand<124> multiplicand<123> multiplicand<122> multiplicand<121> multiplicand<120> multiplicand<119> multiplicand<118> multiplicand<117> multiplicand<116> multiplicand<115> multiplicand<114> multiplicand<113> multiplicand<112> multiplicand<111> multiplicand<110> multiplicand<109> multiplicand<108> multiplicand<107> multiplicand<106> multiplicand<105> multiplicand<104> multiplicand<103> multiplicand<102>
+multiplicand<101> multiplicand<100> multiplicand<99> multiplicand<98> multiplicand<97> multiplicand<96> multiplicand<95> multiplicand<94> multiplicand<93> multiplicand<92> multiplicand<91> multiplicand<90> multiplicand<89> multiplicand<88> multiplicand<87> multiplicand<86> multiplicand<85> multiplicand<84> multiplicand<83> multiplicand<82> multiplicand<81> multiplicand<80> multiplicand<79> multiplicand<78> multiplicand<77> multiplicand<76> multiplicand<75> multiplicand<74> multiplicand<73> multiplicand<72> multiplicand<71> multiplicand<70> multiplicand<69> multiplicand<68> multiplicand<67> multiplicand<66> multiplicand<65> multiplicand<64> multiplicand<63> multiplicand<62> multiplicand<61> multiplicand<60> multiplicand<59> multiplicand<58> multiplicand<57> multiplicand<56> multiplicand<55> multiplicand<54> multiplicand<53> multiplicand<52> multiplicand<51> multiplicand<50> multiplicand<49> multiplicand<48> multiplicand<47> multiplicand<46> multiplicand<45> multiplicand<44> multiplicand<43> multiplicand<42>
+multiplicand<41> multiplicand<40> multiplicand<39> multiplicand<38> multiplicand<37> multiplicand<36> multiplicand<35> multiplicand<34> multiplicand<33> multiplicand<32> multiplicand<31> multiplicand<30> multiplicand<29> multiplicand<28> multiplicand<27> multiplicand<26> multiplicand<25> multiplicand<24> multiplicand<23> multiplicand<22> multiplicand<21> multiplicand<20> multiplicand<19> multiplicand<18> multiplicand<17> multiplicand<16> multiplier<95> multiplier<94> multiplier<93> multiplier<92> multiplier<91> multiplier<90> multiplier<89> multiplier<88> multiplier<87> multiplier<86> multiplier<85> multiplier<84> multiplier<83> multiplier<82> multiplier<81> multiplier<80> multiplier<79> multiplier<78> multiplier<77> multiplier<76> multiplier<75> multiplier<74> multiplier<73> multiplier<72> multiplier<71> multiplier<70> multiplier<69> multiplier<68> multiplier<67> multiplier<66> multiplier<65> multiplier<64> multiplier<63> multiplier<62> multiplier<61> multiplier<60> multiplier<59> multiplier<58>
+multiplier<57> multiplier<56> multiplier<55> multiplier<54> multiplier<53> multiplier<52> multiplier<51> multiplier<50> multiplier<49> multiplier<48> multiplier<47> multiplier<46> multiplier<45> multiplier<44> multiplier<43> multiplier<42> multiplier<41> multiplier<40> multiplier<39> multiplier<38> multiplier<37> multiplier<36> multiplier<35> multiplier<34> multiplier<33> multiplier<32> multiplier<31> multiplier<30> multiplier<29> multiplier<28> multiplier<27> multiplier<26> multiplier<25> multiplier<24> multiplier<23> multiplier<22> multiplier<21> multiplier<20> multiplier<19> multiplier<18> multiplier<17> multiplier<16> multiplier<15> multiplier<14> multiplier<13> multiplier<12> result<10> result<9> result<8>
xi1 multiplicand<79> multiplicand<78> multiplicand<77> multiplicand<76> multiplicand<75> multiplicand<74> multiplicand<73> multiplicand<72> multiplicand<71> multiplicand<70> multiplicand<69> multiplicand<68> multiplicand<67> multiplicand<66> multiplicand<65> multiplicand<64> multiplier<59> multiplier<58> multiplier<57> multiplier<56> multiplier<55> multiplier<54> multiplier<53> multiplier<52> multiplier<51> multiplier<50> multiplier<49> multiplier<48> net09<2> net09<3> net09<4> net09<5> net09<6> net09<7> net09<8> net09<9> multiplicand<127> multiplicand<126> multiplicand<125> multiplicand<124> multiplicand<123> multiplicand<122> multiplicand<121> multiplicand<120> multiplicand<119> multiplicand<118> multiplicand<117> multiplicand<116> multiplicand<115> multiplicand<114> multiplicand<113> multiplicand<112> multiplicand<111> multiplicand<110> multiplicand<109> multiplicand<108> multiplicand<107> multiplicand<106> multiplicand<105> multiplicand<104> multiplicand<103> multiplicand<102> multiplicand<101>
+multiplicand<100> multiplicand<99> multiplicand<98> multiplicand<97> multiplicand<96> multiplicand<95> multiplicand<94> multiplicand<93> multiplicand<92> multiplicand<91> multiplicand<90> multiplicand<89> multiplicand<88> multiplicand<87> multiplicand<86> multiplicand<85> multiplicand<84> multiplicand<83> multiplicand<82> multiplicand<81> multiplicand<80> multiplier<95> multiplier<94> multiplier<93> multiplier<92> multiplier<91> multiplier<90> multiplier<89> multiplier<88> multiplier<87> multiplier<86> multiplier<85> multiplier<84> multiplier<83> multiplier<82> multiplier<81> multiplier<80> multiplier<79> multiplier<78> multiplier<77> multiplier<76> multiplier<75> multiplier<74> multiplier<73> multiplier<72> multiplier<71> multiplier<70> multiplier<69> multiplier<68> multiplier<67> multiplier<66> multiplier<65> multiplier<64> multiplier<63> multiplier<62> multiplier<61> multiplier<60> net09<0> net09<1> myMAC_16_3bit_4bit
xi0 multiplicand<15> multiplicand<14> multiplicand<13> multiplicand<12> multiplicand<11> multiplicand<10> multiplicand<9> multiplicand<8> multiplicand<7> multiplicand<6> multiplicand<5> multiplicand<4> multiplicand<3> multiplicand<2> multiplicand<1> multiplicand<0> multiplier<11> multiplier<10> multiplier<9> multiplier<8> multiplier<7> multiplier<6> multiplier<5> multiplier<4> multiplier<3> multiplier<2> multiplier<1> multiplier<0> net010<2> net010<3> net010<4> net010<5> net010<6> net010<7> net010<8> net010<9> multiplicand<63> multiplicand<62> multiplicand<61> multiplicand<60> multiplicand<59> multiplicand<58> multiplicand<57> multiplicand<56> multiplicand<55> multiplicand<54> multiplicand<53> multiplicand<52> multiplicand<51> multiplicand<50> multiplicand<49> multiplicand<48> multiplicand<47> multiplicand<46> multiplicand<45> multiplicand<44> multiplicand<43> multiplicand<42> multiplicand<41> multiplicand<40> multiplicand<39> multiplicand<38> multiplicand<37> multiplicand<36> multiplicand<35>
+multiplicand<34> multiplicand<33> multiplicand<32> multiplicand<31> multiplicand<30> multiplicand<29> multiplicand<28> multiplicand<27> multiplicand<26> multiplicand<25> multiplicand<24> multiplicand<23> multiplicand<22> multiplicand<21> multiplicand<20> multiplicand<19> multiplicand<18> multiplicand<17> multiplicand<16> multiplier<47> multiplier<46> multiplier<45> multiplier<44> multiplier<43> multiplier<42> multiplier<41> multiplier<40> multiplier<39> multiplier<38> multiplier<37> multiplier<36> multiplier<35> multiplier<34> multiplier<33> multiplier<32> multiplier<31> multiplier<30> multiplier<29> multiplier<28> multiplier<27> multiplier<26> multiplier<25> multiplier<24> multiplier<23> multiplier<22> multiplier<21> multiplier<20> multiplier<19> multiplier<18> multiplier<17> multiplier<16> multiplier<15> multiplier<14> multiplier<13> multiplier<12> net010<0> net010<1> myMAC_16_3bit_4bit
xi2 net010<3> net010<4> net010<5> net010<6> net010<7> net010<8> net010<9> net09<3> net09<4> net09<5> net09<6> net09<7> net09<8> net09<9> 0 result<7> result<6> result<5> result<4> result<3> result<2> result<1> result<0> net010<0> net010<1> net010<2> net09<0> net09<1> net09<2> result<10> result<9> result<8> myAdder_10bit
.ends myMAC_32_3bit_4bit
** End of subcircuit definition.

** Library name: MyLibPDK45
** Cell name: myMAC_64_3bit_4bit
** View name: schematic
xi2 net013<4> net013<5> net013<6> net013<7> net013<8> net013<9> net013<10> net012<4> net012<5> net012<6> net012<7> net012<8> net012<9> net012<10> 0 s<7> s<6> s<5> s<4> s<3> s<2> s<1> s<0> net013<0> net013<1> net013<2> net013<3> net012<0> net012<1> net012<2> net012<3> s<11> s<10> s<9> s<8> myAdder_11bit
xi16 s<11> result<11> myBuffer_2
xi15 s<10> result<10> myBuffer_2
xi14 s<9> result<9> myBuffer_2
xi13 s<8> result<8> myBuffer_2
xi12 s<7> result<7> myBuffer_2
xi11 s<6> result<6> myBuffer_2
xi10 s<5> result<5> myBuffer_2
xi9 s<4> result<4> myBuffer_2
xi8 s<3> result<3> myBuffer_2
xi7 s<2> result<2> myBuffer_2
xi6 s<1> result<1> myBuffer_2
xi5 s<0> result<0> myBuffer_2
xi1 multiplicand<143> multiplicand<142> multiplicand<141> multiplicand<140> multiplicand<139> multiplicand<138> multiplicand<137> multiplicand<136> multiplicand<135> multiplicand<134> multiplicand<133> multiplicand<132> multiplicand<131> multiplicand<130> multiplicand<129> multiplicand<128> multiplier<107> multiplier<106> multiplier<105> multiplier<104> multiplier<103> multiplier<102> multiplier<101> multiplier<100> multiplier<99> multiplier<98> multiplier<97> multiplier<96> net012<3> net012<4> net012<5> net012<6> net012<7> net012<8> net012<9> net012<10> multiplicand<255> multiplicand<254> multiplicand<253> multiplicand<252> multiplicand<251> multiplicand<250> multiplicand<249> multiplicand<248> multiplicand<247> multiplicand<246> multiplicand<245> multiplicand<244> multiplicand<243> multiplicand<242> multiplicand<241> multiplicand<240> multiplicand<239> multiplicand<238> multiplicand<237> multiplicand<236> multiplicand<235> multiplicand<234> multiplicand<233> multiplicand<232> multiplicand<231>
+multiplicand<230> multiplicand<229> multiplicand<228> multiplicand<227> multiplicand<226> multiplicand<225> multiplicand<224> multiplicand<223> multiplicand<222> multiplicand<221> multiplicand<220> multiplicand<219> multiplicand<218> multiplicand<217> multiplicand<216> multiplicand<215> multiplicand<214> multiplicand<213> multiplicand<212> multiplicand<211> multiplicand<210> multiplicand<209> multiplicand<208> multiplicand<207> multiplicand<206> multiplicand<205> multiplicand<204> multiplicand<203> multiplicand<202> multiplicand<201> multiplicand<200> multiplicand<199> multiplicand<198> multiplicand<197> multiplicand<196> multiplicand<195> multiplicand<194> multiplicand<193> multiplicand<192> multiplicand<191> multiplicand<190> multiplicand<189> multiplicand<188> multiplicand<187> multiplicand<186> multiplicand<185> multiplicand<184> multiplicand<183> multiplicand<182> multiplicand<181> multiplicand<180> multiplicand<179> multiplicand<178> multiplicand<177> multiplicand<176> multiplicand<175>
+multiplicand<174> multiplicand<173> multiplicand<172> multiplicand<171> multiplicand<170> multiplicand<169> multiplicand<168> multiplicand<167> multiplicand<166> multiplicand<165> multiplicand<164> multiplicand<163> multiplicand<162> multiplicand<161> multiplicand<160> multiplicand<159> multiplicand<158> multiplicand<157> multiplicand<156> multiplicand<155> multiplicand<154> multiplicand<153> multiplicand<152> multiplicand<151> multiplicand<150> multiplicand<149> multiplicand<148> multiplicand<147> multiplicand<146> multiplicand<145> multiplicand<144> multiplier<191> multiplier<190> multiplier<189> multiplier<188> multiplier<187> multiplier<186> multiplier<185> multiplier<184> multiplier<183> multiplier<182> multiplier<181> multiplier<180> multiplier<179> multiplier<178> multiplier<177> multiplier<176> multiplier<175> multiplier<174> multiplier<173> multiplier<172> multiplier<171> multiplier<170> multiplier<169> multiplier<168> multiplier<167> multiplier<166> multiplier<165> multiplier<164> multiplier<163>
+multiplier<162> multiplier<161> multiplier<160> multiplier<159> multiplier<158> multiplier<157> multiplier<156> multiplier<155> multiplier<154> multiplier<153> multiplier<152> multiplier<151> multiplier<150> multiplier<149> multiplier<148> multiplier<147> multiplier<146> multiplier<145> multiplier<144> multiplier<143> multiplier<142> multiplier<141> multiplier<140> multiplier<139> multiplier<138> multiplier<137> multiplier<136> multiplier<135> multiplier<134> multiplier<133> multiplier<132> multiplier<131> multiplier<130> multiplier<129> multiplier<128> multiplier<127> multiplier<126> multiplier<125> multiplier<124> multiplier<123> multiplier<122> multiplier<121> multiplier<120> multiplier<119> multiplier<118> multiplier<117> multiplier<116> multiplier<115> multiplier<114> multiplier<113> multiplier<112> multiplier<111> multiplier<110> multiplier<109> multiplier<108> net012<0> net012<1> net012<2> myMAC_32_3bit_4bit
xi0 multiplicand<15> multiplicand<14> multiplicand<13> multiplicand<12> multiplicand<11> multiplicand<10> multiplicand<9> multiplicand<8> multiplicand<7> multiplicand<6> multiplicand<5> multiplicand<4> multiplicand<3> multiplicand<2> multiplicand<1> multiplicand<0> multiplier<11> multiplier<10> multiplier<9> multiplier<8> multiplier<7> multiplier<6> multiplier<5> multiplier<4> multiplier<3> multiplier<2> multiplier<1> multiplier<0> net013<3> net013<4> net013<5> net013<6> net013<7> net013<8> net013<9> net013<10> multiplicand<127> multiplicand<126> multiplicand<125> multiplicand<124> multiplicand<123> multiplicand<122> multiplicand<121> multiplicand<120> multiplicand<119> multiplicand<118> multiplicand<117> multiplicand<116> multiplicand<115> multiplicand<114> multiplicand<113> multiplicand<112> multiplicand<111> multiplicand<110> multiplicand<109> multiplicand<108> multiplicand<107> multiplicand<106> multiplicand<105> multiplicand<104> multiplicand<103> multiplicand<102> multiplicand<101> multiplicand<100>
+multiplicand<99> multiplicand<98> multiplicand<97> multiplicand<96> multiplicand<95> multiplicand<94> multiplicand<93> multiplicand<92> multiplicand<91> multiplicand<90> multiplicand<89> multiplicand<88> multiplicand<87> multiplicand<86> multiplicand<85> multiplicand<84> multiplicand<83> multiplicand<82> multiplicand<81> multiplicand<80> multiplicand<79> multiplicand<78> multiplicand<77> multiplicand<76> multiplicand<75> multiplicand<74> multiplicand<73> multiplicand<72> multiplicand<71> multiplicand<70> multiplicand<69> multiplicand<68> multiplicand<67> multiplicand<66> multiplicand<65> multiplicand<64> multiplicand<63> multiplicand<62> multiplicand<61> multiplicand<60> multiplicand<59> multiplicand<58> multiplicand<57> multiplicand<56> multiplicand<55> multiplicand<54> multiplicand<53> multiplicand<52> multiplicand<51> multiplicand<50> multiplicand<49> multiplicand<48> multiplicand<47> multiplicand<46> multiplicand<45> multiplicand<44> multiplicand<43> multiplicand<42> multiplicand<41> multiplicand<40>
+multiplicand<39> multiplicand<38> multiplicand<37> multiplicand<36> multiplicand<35> multiplicand<34> multiplicand<33> multiplicand<32> multiplicand<31> multiplicand<30> multiplicand<29> multiplicand<28> multiplicand<27> multiplicand<26> multiplicand<25> multiplicand<24> multiplicand<23> multiplicand<22> multiplicand<21> multiplicand<20> multiplicand<19> multiplicand<18> multiplicand<17> multiplicand<16> multiplier<95> multiplier<94> multiplier<93> multiplier<92> multiplier<91> multiplier<90> multiplier<89> multiplier<88> multiplier<87> multiplier<86> multiplier<85> multiplier<84> multiplier<83> multiplier<82> multiplier<81> multiplier<80> multiplier<79> multiplier<78> multiplier<77> multiplier<76> multiplier<75> multiplier<74> multiplier<73> multiplier<72> multiplier<71> multiplier<70> multiplier<69> multiplier<68> multiplier<67> multiplier<66> multiplier<65> multiplier<64> multiplier<63> multiplier<62> multiplier<61> multiplier<60> multiplier<59> multiplier<58> multiplier<57> multiplier<56> multiplier<55>
+multiplier<54> multiplier<53> multiplier<52> multiplier<51> multiplier<50> multiplier<49> multiplier<48> multiplier<47> multiplier<46> multiplier<45> multiplier<44> multiplier<43> multiplier<42> multiplier<41> multiplier<40> multiplier<39> multiplier<38> multiplier<37> multiplier<36> multiplier<35> multiplier<34> multiplier<33> multiplier<32> multiplier<31> multiplier<30> multiplier<29> multiplier<28> multiplier<27> multiplier<26> multiplier<25> multiplier<24> multiplier<23> multiplier<22> multiplier<21> multiplier<20> multiplier<19> multiplier<18> multiplier<17> multiplier<16> multiplier<15> multiplier<14> multiplier<13> multiplier<12> net013<0> net013<1> net013<2> myMAC_32_3bit_4bit
.ends MAC_64
