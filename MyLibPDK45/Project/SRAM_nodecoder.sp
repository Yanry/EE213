** Generated for: hspiceD
** Generated on: Dec 18 18:35:09 2024
** Design library name: EE213CAN45nm
** Design cell name: SRAM_TOTAL_tb
** Design view name: schematic
.GLOBAL vdd!

.TEMP 25.0
.OPTION
+    ARTIST=2
+    INGOLD=2
+    PARHIER=LOCAL
+    PSF=2

** Library name: EE213CAN45nm
** Cell name: precharge
** View name: schematic
.subckt precharge prc b b1
m2 b prc vdd! vdd! PMOS_VTL L=50e-9 W=180e-9 AD=9.45e-15 AS=9.45e-15 PD=300e-9 PS=300e-9 M=1
m1 b prc b1 vdd! PMOS_VTL L=50e-9 W=180e-9 AD=9.45e-15 AS=9.45e-15 PD=300e-9 PS=300e-9 M=1
m0 b1 prc vdd! vdd! PMOS_VTL L=50e-9 W=180e-9 AD=9.45e-15 AS=9.45e-15 PD=300e-9 PS=300e-9 M=1
.ends precharge
** End of subcircuit definition.

** Library name: EE213CAN45nm
** Cell name: pre_2
** View name: schematic
.subckt pre_2 prc b1<0> b1<1> b<0> b<1>
xi5 prc b<1> b1<1> precharge
xi4 prc b<0> b1<0> precharge
.ends pre_2
** End of subcircuit definition.

** Library name: EE213CAN45nm
** Cell name: pre_4
** View name: schematic
.subckt pre_4 prc b1<0> b1<1> b1<2> b1<3> b<0> b<1> b<2> b<3>
xi1 prc b1<0> b1<1> b<0> b<1> pre_2
xi0 prc b1<2> b1<3> b<2> b<3> pre_2
.ends pre_4
** End of subcircuit definition.

** Library name: EE213CAN45nm
** Cell name: pre_8
** View name: schematic
.subckt pre_8 prc b1<7> b1<6> b1<5> b1<4> b1<3> b1<2> b1<1> b1<0> b<7> b<6> b<5> b<4> b<3> b<2> b<1> b<0>
xi1 prc b1<3> b1<2> b1<1> b1<0> b<3> b<2> b<1> b<0> pre_4
xi0 prc b1<7> b1<6> b1<5> b1<4> b<7> b<6> b<5> b<4> pre_4
.ends pre_8
** End of subcircuit definition.

** Library name: EE213CAN45nm
** Cell name: pre_16
** View name: schematic
.subckt pre_16 prc b1<15> b1<14> b1<13> b1<12> b1<11> b1<10> b1<9> b1<8> b1<7> b1<6> b1<5> b1<4> b1<3> b1<2> b1<1> b1<0> b<15> b<14> b<13> b<12> b<11> b<10> b<9> b<8> b<7> b<6> b<5> b<4> b<3> b<2> b<1> b<0>
xi1 prc b1<7> b1<6> b1<5> b1<4> b1<3> b1<2> b1<1> b1<0> b<7> b<6> b<5> b<4> b<3> b<2> b<1> b<0> pre_8
xi0 prc b1<15> b1<14> b1<13> b1<12> b1<11> b1<10> b1<9> b1<8> b<15> b<14> b<13> b<12> b<11> b<10> b<9> b<8> pre_8
.ends pre_16
** End of subcircuit definition.

** Library name: EE213CAN45nm
** Cell name: pre_32
** View name: schematic
.subckt pre_32 prc b1<31> b1<30> b1<29> b1<28> b1<27> b1<26> b1<25> b1<24> b1<23> b1<22> b1<21> b1<20> b1<19> b1<18> b1<17> b1<16> b1<15> b1<14> b1<13> b1<12> b1<11> b1<10> b1<9> b1<8> b1<7> b1<6> b1<5> b1<4> b1<3> b1<2> b1<1> b1<0> b<31> b<30> b<29> b<28> b<27> b<26> b<25> b<24> b<23> b<22> b<21> b<20> b<19> b<18> b<17> b<16> b<15> b<14> b<13> b<12> b<11> b<10> b<9> b<8> b<7> b<6> b<5> b<4> b<3> b<2> b<1> b<0>
xi1 prc b1<15> b1<14> b1<13> b1<12> b1<11> b1<10> b1<9> b1<8> b1<7> b1<6> b1<5> b1<4> b1<3> b1<2> b1<1> b1<0> b<15> b<14> b<13> b<12> b<11> b<10> b<9> b<8> b<7> b<6> b<5> b<4> b<3> b<2> b<1> b<0> pre_16
xi0 prc b1<31> b1<30> b1<29> b1<28> b1<27> b1<26> b1<25> b1<24> b1<23> b1<22> b1<21> b1<20> b1<19> b1<18> b1<17> b1<16> b<31> b<30> b<29> b<28> b<27> b<26> b<25> b<24> b<23> b<22> b<21> b<20> b<19> b<18> b<17> b<16> pre_16
.ends pre_32
** End of subcircuit definition.

** Library name: EE213CAN45nm
** Cell name: pre_64
** View name: schematic
.subckt pre_64 prc b1<63> b1<62> b1<61> b1<60> b1<59> b1<58> b1<57> b1<56> b1<55> b1<54> b1<53> b1<52> b1<51> b1<50> b1<49> b1<48> b1<47> b1<46> b1<45> b1<44> b1<43> b1<42> b1<41> b1<40> b1<39> b1<38> b1<37> b1<36> b1<35> b1<34> b1<33> b1<32> b1<31> b1<30> b1<29> b1<28> b1<27> b1<26> b1<25> b1<24> b1<23> b1<22> b1<21> b1<20> b1<19> b1<18> b1<17> b1<16> b1<15> b1<14> b1<13> b1<12> b1<11> b1<10> b1<9> b1<8> b1<7> b1<6> b1<5> b1<4> b1<3> b1<2> b1<1> b1<0> b<63> b<62> b<61> b<60> b<59> b<58> b<57> b<56> b<55> b<54> b<53> b<52> b<51> b<50> b<49> b<48> b<47> b<46> b<45> b<44> b<43> b<42> b<41> b<40> b<39> b<38> b<37> b<36> b<35> b<34> b<33> b<32> b<31> b<30> b<29> b<28> b<27> b<26> b<25> b<24> b<23> b<22> b<21> b<20> b<19> b<18> b<17> b<16> b<15> b<14> b<13> b<12> b<11> b<10> b<9> b<8> b<7> b<6> b<5> b<4> b<3> b<2> b<1> b<0>
xi1 prc b1<31> b1<30> b1<29> b1<28> b1<27> b1<26> b1<25> b1<24> b1<23> b1<22> b1<21> b1<20> b1<19> b1<18> b1<17> b1<16> b1<15> b1<14> b1<13> b1<12> b1<11> b1<10> b1<9> b1<8> b1<7> b1<6> b1<5> b1<4> b1<3> b1<2> b1<1> b1<0> b<31> b<30> b<29> b<28> b<27> b<26> b<25> b<24> b<23> b<22> b<21> b<20> b<19> b<18> b<17> b<16> b<15> b<14> b<13> b<12> b<11> b<10> b<9> b<8> b<7> b<6> b<5> b<4> b<3> b<2> b<1> b<0> pre_32
xi0 prc b1<63> b1<62> b1<61> b1<60> b1<59> b1<58> b1<57> b1<56> b1<55> b1<54> b1<53> b1<52> b1<51> b1<50> b1<49> b1<48> b1<47> b1<46> b1<45> b1<44> b1<43> b1<42> b1<41> b1<40> b1<39> b1<38> b1<37> b1<36> b1<35> b1<34> b1<33> b1<32> b<63> b<62> b<61> b<60> b<59> b<58> b<57> b<56> b<55> b<54> b<53> b<52> b<51> b<50> b<49> b<48> b<47> b<46> b<45> b<44> b<43> b<42> b<41> b<40> b<39> b<38> b<37> b<36> b<35> b<34> b<33> b<32> pre_32
.ends pre_64
** End of subcircuit definition.

** Library name: EE213CAN45nm
** Cell name: pre_192
** View name: schematic
.subckt pre_192 prc b1<191> b1<190> b1<189> b1<188> b1<187> b1<186> b1<185> b1<184> b1<183> b1<182> b1<181> b1<180> b1<179> b1<178> b1<177> b1<176> b1<175> b1<174> b1<173> b1<172> b1<171> b1<170> b1<169> b1<168> b1<167> b1<166> b1<165> b1<164> b1<163> b1<162> b1<161> b1<160> b1<159> b1<158> b1<157> b1<156> b1<155> b1<154> b1<153> b1<152> b1<151> b1<150> b1<149> b1<148> b1<147> b1<146> b1<145> b1<144> b1<143> b1<142> b1<141> b1<140> b1<139> b1<138> b1<137> b1<136> b1<135> b1<134> b1<133> b1<132> b1<131> b1<130> b1<129> b1<128> b1<127> b1<126> b1<125> b1<124> b1<123> b1<122> b1<121> b1<120> b1<119> b1<118> b1<117> b1<116> b1<115> b1<114> b1<113> b1<112> b1<111> b1<110> b1<109> b1<108> b1<107> b1<106> b1<105> b1<104> b1<103> b1<102> b1<101> b1<100> b1<99> b1<98> b1<97> b1<96> b1<95> b1<94> b1<93> b1<92> b1<91> b1<90> b1<89> b1<88> b1<87> b1<86> b1<85> b1<84> b1<83> b1<82> b1<81> b1<80> b1<79> b1<78> b1<77> b1<76> b1<75> b1<74> b1<73> b1<72> b1<71> b1<70> b1<69> b1<68> b1<67> b1<66> b1<65> b1<64> b1<63> b1<62>
+b1<61> b1<60> b1<59> b1<58> b1<57> b1<56> b1<55> b1<54> b1<53> b1<52> b1<51> b1<50> b1<49> b1<48> b1<47> b1<46> b1<45> b1<44> b1<43> b1<42> b1<41> b1<40> b1<39> b1<38> b1<37> b1<36> b1<35> b1<34> b1<33> b1<32> b1<31> b1<30> b1<29> b1<28> b1<27> b1<26> b1<25> b1<24> b1<23> b1<22> b1<21> b1<20> b1<19> b1<18> b1<17> b1<16> b1<15> b1<14> b1<13> b1<12> b1<11> b1<10> b1<9> b1<8> b1<7> b1<6> b1<5> b1<4> b1<3> b1<2> b1<1> b1<0> b<191> b<190> b<189> b<188> b<187> b<186> b<185> b<184> b<183> b<182> b<181> b<180> b<179> b<178> b<177> b<176> b<175> b<174> b<173> b<172> b<171> b<170> b<169> b<168> b<167> b<166> b<165> b<164> b<163> b<162> b<161> b<160> b<159> b<158> b<157> b<156> b<155> b<154> b<153> b<152> b<151> b<150> b<149> b<148> b<147> b<146> b<145> b<144> b<143> b<142> b<141> b<140> b<139> b<138> b<137> b<136> b<135> b<134> b<133> b<132> b<131> b<130> b<129> b<128> b<127> b<126> b<125> b<124> b<123> b<122> b<121> b<120> b<119> b<118> b<117> b<116> b<115> b<114> b<113> b<112> b<111> b<110> b<109> b<108> b<107>
+b<106> b<105> b<104> b<103> b<102> b<101> b<100> b<99> b<98> b<97> b<96> b<95> b<94> b<93> b<92> b<91> b<90> b<89> b<88> b<87> b<86> b<85> b<84> b<83> b<82> b<81> b<80> b<79> b<78> b<77> b<76> b<75> b<74> b<73> b<72> b<71> b<70> b<69> b<68> b<67> b<66> b<65> b<64> b<63> b<62> b<61> b<60> b<59> b<58> b<57> b<56> b<55> b<54> b<53> b<52> b<51> b<50> b<49> b<48> b<47> b<46> b<45> b<44> b<43> b<42> b<41> b<40> b<39> b<38> b<37> b<36> b<35> b<34> b<33> b<32> b<31> b<30> b<29> b<28> b<27> b<26> b<25> b<24> b<23> b<22> b<21> b<20> b<19> b<18> b<17> b<16> b<15> b<14> b<13> b<12> b<11> b<10> b<9> b<8> b<7> b<6> b<5> b<4> b<3> b<2> b<1> b<0>
xi2 prc b1<191> b1<190> b1<189> b1<188> b1<187> b1<186> b1<185> b1<184> b1<183> b1<182> b1<181> b1<180> b1<179> b1<178> b1<177> b1<176> b1<175> b1<174> b1<173> b1<172> b1<171> b1<170> b1<169> b1<168> b1<167> b1<166> b1<165> b1<164> b1<163> b1<162> b1<161> b1<160> b1<159> b1<158> b1<157> b1<156> b1<155> b1<154> b1<153> b1<152> b1<151> b1<150> b1<149> b1<148> b1<147> b1<146> b1<145> b1<144> b1<143> b1<142> b1<141> b1<140> b1<139> b1<138> b1<137> b1<136> b1<135> b1<134> b1<133> b1<132> b1<131> b1<130> b1<129> b1<128> b<191> b<190> b<189> b<188> b<187> b<186> b<185> b<184> b<183> b<182> b<181> b<180> b<179> b<178> b<177> b<176> b<175> b<174> b<173> b<172> b<171> b<170> b<169> b<168> b<167> b<166> b<165> b<164> b<163> b<162> b<161> b<160> b<159> b<158> b<157> b<156> b<155> b<154> b<153> b<152> b<151> b<150> b<149> b<148> b<147> b<146> b<145> b<144> b<143> b<142> b<141> b<140> b<139> b<138> b<137> b<136> b<135> b<134> b<133> b<132> b<131> b<130> b<129> b<128> pre_64
xi1 prc b1<63> b1<62> b1<61> b1<60> b1<59> b1<58> b1<57> b1<56> b1<55> b1<54> b1<53> b1<52> b1<51> b1<50> b1<49> b1<48> b1<47> b1<46> b1<45> b1<44> b1<43> b1<42> b1<41> b1<40> b1<39> b1<38> b1<37> b1<36> b1<35> b1<34> b1<33> b1<32> b1<31> b1<30> b1<29> b1<28> b1<27> b1<26> b1<25> b1<24> b1<23> b1<22> b1<21> b1<20> b1<19> b1<18> b1<17> b1<16> b1<15> b1<14> b1<13> b1<12> b1<11> b1<10> b1<9> b1<8> b1<7> b1<6> b1<5> b1<4> b1<3> b1<2> b1<1> b1<0> b<63> b<62> b<61> b<60> b<59> b<58> b<57> b<56> b<55> b<54> b<53> b<52> b<51> b<50> b<49> b<48> b<47> b<46> b<45> b<44> b<43> b<42> b<41> b<40> b<39> b<38> b<37> b<36> b<35> b<34> b<33> b<32> b<31> b<30> b<29> b<28> b<27> b<26> b<25> b<24> b<23> b<22> b<21> b<20> b<19> b<18> b<17> b<16> b<15> b<14> b<13> b<12> b<11> b<10> b<9> b<8> b<7> b<6> b<5> b<4> b<3> b<2> b<1> b<0> pre_64
xi0 prc b1<127> b1<126> b1<125> b1<124> b1<123> b1<122> b1<121> b1<120> b1<119> b1<118> b1<117> b1<116> b1<115> b1<114> b1<113> b1<112> b1<111> b1<110> b1<109> b1<108> b1<107> b1<106> b1<105> b1<104> b1<103> b1<102> b1<101> b1<100> b1<99> b1<98> b1<97> b1<96> b1<95> b1<94> b1<93> b1<92> b1<91> b1<90> b1<89> b1<88> b1<87> b1<86> b1<85> b1<84> b1<83> b1<82> b1<81> b1<80> b1<79> b1<78> b1<77> b1<76> b1<75> b1<74> b1<73> b1<72> b1<71> b1<70> b1<69> b1<68> b1<67> b1<66> b1<65> b1<64> b<127> b<126> b<125> b<124> b<123> b<122> b<121> b<120> b<119> b<118> b<117> b<116> b<115> b<114> b<113> b<112> b<111> b<110> b<109> b<108> b<107> b<106> b<105> b<104> b<103> b<102> b<101> b<100> b<99> b<98> b<97> b<96> b<95> b<94> b<93> b<92> b<91> b<90> b<89> b<88> b<87> b<86> b<85> b<84> b<83> b<82> b<81> b<80> b<79> b<78> b<77> b<76> b<75> b<74> b<73> b<72> b<71> b<70> b<69> b<68> b<67> b<66> b<65> b<64> pre_64
.ends pre_192
** End of subcircuit definition.

** Library name: EE213CAN45nm
** Cell name: SRAM
** View name: schematic
.subckt SRAM w b b1
m5 b1 w q1 0 NMOS_VTL L=50e-9 W=90e-9 AD=9.45e-15 AS=9.45e-15 PD=300e-9 PS=300e-9 M=1
m4 q w b 0 NMOS_VTL L=50e-9 W=90e-9 AD=9.45e-15 AS=9.45e-15 PD=300e-9 PS=300e-9 M=1
m3 q1 q 0 0 NMOS_VTL L=50e-9 W=90e-9 AD=9.45e-15 AS=9.45e-15 PD=300e-9 PS=300e-9 M=1
m0 q q1 0 0 NMOS_VTL L=50e-9 W=90e-9 AD=9.45e-15 AS=9.45e-15 PD=300e-9 PS=300e-9 M=1
m2 q1 q vdd! vdd! PMOS_VTL L=50e-9 W=180e-9 AD=9.45e-15 AS=9.45e-15 PD=300e-9 PS=300e-9 M=1
m1 q q1 vdd! vdd! PMOS_VTL L=50e-9 W=180e-9 AD=9.45e-15 AS=9.45e-15 PD=300e-9 PS=300e-9 M=1
.ends SRAM
** End of subcircuit definition.

** Library name: EE213CAN45nm
** Cell name: SRAM_2
** View name: schematic
.subckt SRAM_2 w b1<1> b1<0> b<1> b<0>
xi1 w b<0> b1<0> SRAM
xi0 w b<1> b1<1> SRAM
.ends SRAM_2
** End of subcircuit definition.

** Library name: EE213CAN45nm
** Cell name: SRAM_4
** View name: schematic
.subckt SRAM_4 w b1<3> b1<2> b1<1> b1<0> b<3> b<2> b<1> b<0>
xi1 w b1<1> b1<0> b<1> b<0> SRAM_2
xi0 w b1<3> b1<2> b<3> b<2> SRAM_2
.ends SRAM_4
** End of subcircuit definition.

** Library name: EE213CAN45nm
** Cell name: SRAM_8
** View name: schematic
.subckt SRAM_8 w b1<7> b1<6> b1<5> b1<4> b1<3> b1<2> b1<1> b1<0> b<7> b<6> b<5> b<4> b<3> b<2> b<1> b<0>
xi1 w b1<0> b1<1> b1<2> b1<3> b<0> b<1> b<2> b<3> SRAM_4
xi0 w b1<4> b1<5> b1<6> b1<7> b<4> b<5> b<6> b<7> SRAM_4
.ends SRAM_8
** End of subcircuit definition.

** Library name: EE213CAN45nm
** Cell name: SRAM_16
** View name: schematic
.subckt SRAM_16 w b1<15> b1<14> b1<13> b1<12> b1<11> b1<10> b1<9> b1<8> b1<7> b1<6> b1<5> b1<4> b1<3> b1<2> b1<1> b1<0> b<15> b<14> b<13> b<12> b<11> b<10> b<9> b<8> b<7> b<6> b<5> b<4> b<3> b<2> b<1> b<0>
xi1 w b1<7> b1<6> b1<5> b1<4> b1<3> b1<2> b1<1> b1<0> b<7> b<6> b<5> b<4> b<3> b<2> b<1> b<0> SRAM_8
xi0 w b1<15> b1<14> b1<13> b1<12> b1<11> b1<10> b1<9> b1<8> b<15> b<14> b<13> b<12> b<11> b<10> b<9> b<8> SRAM_8
.ends SRAM_16
** End of subcircuit definition.

** Library name: EE213CAN45nm
** Cell name: SRAM_32
** View name: schematic
.subckt SRAM_32 w b1<31> b1<30> b1<29> b1<28> b1<27> b1<26> b1<25> b1<24> b1<23> b1<22> b1<21> b1<20> b1<19> b1<18> b1<17> b1<16> b1<15> b1<14> b1<13> b1<12> b1<11> b1<10> b1<9> b1<8> b1<7> b1<6> b1<5> b1<4> b1<3> b1<2> b1<1> b1<0> b<31> b<30> b<29> b<28> b<27> b<26> b<25> b<24> b<23> b<22> b<21> b<20> b<19> b<18> b<17> b<16> b<15> b<14> b<13> b<12> b<11> b<10> b<9> b<8> b<7> b<6> b<5> b<4> b<3> b<2> b<1> b<0>
xi1 w b1<31> b1<30> b1<29> b1<28> b1<27> b1<26> b1<25> b1<24> b1<23> b1<22> b1<21> b1<20> b1<19> b1<18> b1<17> b1<16> b<31> b<30> b<29> b<28> b<27> b<26> b<25> b<24> b<23> b<22> b<21> b<20> b<19> b<18> b<17> b<16> SRAM_16
xi0 w b1<15> b1<14> b1<13> b1<12> b1<11> b1<10> b1<9> b1<8> b1<7> b1<6> b1<5> b1<4> b1<3> b1<2> b1<1> b1<0> b<15> b<14> b<13> b<12> b<11> b<10> b<9> b<8> b<7> b<6> b<5> b<4> b<3> b<2> b<1> b<0> SRAM_16
.ends SRAM_32
** End of subcircuit definition.

** Library name: EE213CAN45nm
** Cell name: SRAM_64
** View name: schematic
.subckt SRAM_64 w b1<63> b1<62> b1<61> b1<60> b1<59> b1<58> b1<57> b1<56> b1<55> b1<54> b1<53> b1<52> b1<51> b1<50> b1<49> b1<48> b1<47> b1<46> b1<45> b1<44> b1<43> b1<42> b1<41> b1<40> b1<39> b1<38> b1<37> b1<36> b1<35> b1<34> b1<33> b1<32> b1<31> b1<30> b1<29> b1<28> b1<27> b1<26> b1<25> b1<24> b1<23> b1<22> b1<21> b1<20> b1<19> b1<18> b1<17> b1<16> b1<15> b1<14> b1<13> b1<12> b1<11> b1<10> b1<9> b1<8> b1<7> b1<6> b1<5> b1<4> b1<3> b1<2> b1<1> b1<0> b<63> b<62> b<61> b<60> b<59> b<58> b<57> b<56> b<55> b<54> b<53> b<52> b<51> b<50> b<49> b<48> b<47> b<46> b<45> b<44> b<43> b<42> b<41> b<40> b<39> b<38> b<37> b<36> b<35> b<34> b<33> b<32> b<31> b<30> b<29> b<28> b<27> b<26> b<25> b<24> b<23> b<22> b<21> b<20> b<19> b<18> b<17> b<16> b<15> b<14> b<13> b<12> b<11> b<10> b<9> b<8> b<7> b<6> b<5> b<4> b<3> b<2> b<1> b<0>
xi1 w b1<31> b1<30> b1<29> b1<28> b1<27> b1<26> b1<25> b1<24> b1<23> b1<22> b1<21> b1<20> b1<19> b1<18> b1<17> b1<16> b1<15> b1<14> b1<13> b1<12> b1<11> b1<10> b1<9> b1<8> b1<7> b1<6> b1<5> b1<4> b1<3> b1<2> b1<1> b1<0> b<31> b<30> b<29> b<28> b<27> b<26> b<25> b<24> b<23> b<22> b<21> b<20> b<19> b<18> b<17> b<16> b<15> b<14> b<13> b<12> b<11> b<10> b<9> b<8> b<7> b<6> b<5> b<4> b<3> b<2> b<1> b<0> SRAM_32
xi0 w b1<63> b1<62> b1<61> b1<60> b1<59> b1<58> b1<57> b1<56> b1<55> b1<54> b1<53> b1<52> b1<51> b1<50> b1<49> b1<48> b1<47> b1<46> b1<45> b1<44> b1<43> b1<42> b1<41> b1<40> b1<39> b1<38> b1<37> b1<36> b1<35> b1<34> b1<33> b1<32> b<63> b<62> b<61> b<60> b<59> b<58> b<57> b<56> b<55> b<54> b<53> b<52> b<51> b<50> b<49> b<48> b<47> b<46> b<45> b<44> b<43> b<42> b<41> b<40> b<39> b<38> b<37> b<36> b<35> b<34> b<33> b<32> SRAM_32
.ends SRAM_64
** End of subcircuit definition.

** Library name: EE213CAN45nm
** Cell name: SRAM_192
** View name: schematic
.subckt SRAM_192 w b1<191> b1<190> b1<189> b1<188> b1<187> b1<186> b1<185> b1<184> b1<183> b1<182> b1<181> b1<180> b1<179> b1<178> b1<177> b1<176> b1<175> b1<174> b1<173> b1<172> b1<171> b1<170> b1<169> b1<168> b1<167> b1<166> b1<165> b1<164> b1<163> b1<162> b1<161> b1<160> b1<159> b1<158> b1<157> b1<156> b1<155> b1<154> b1<153> b1<152> b1<151> b1<150> b1<149> b1<148> b1<147> b1<146> b1<145> b1<144> b1<143> b1<142> b1<141> b1<140> b1<139> b1<138> b1<137> b1<136> b1<135> b1<134> b1<133> b1<132> b1<131> b1<130> b1<129> b1<128> b1<127> b1<126> b1<125> b1<124> b1<123> b1<122> b1<121> b1<120> b1<119> b1<118> b1<117> b1<116> b1<115> b1<114> b1<113> b1<112> b1<111> b1<110> b1<109> b1<108> b1<107> b1<106> b1<105> b1<104> b1<103> b1<102> b1<101> b1<100> b1<99> b1<98> b1<97> b1<96> b1<95> b1<94> b1<93> b1<92> b1<91> b1<90> b1<89> b1<88> b1<87> b1<86> b1<85> b1<84> b1<83> b1<82> b1<81> b1<80> b1<79> b1<78> b1<77> b1<76> b1<75> b1<74> b1<73> b1<72> b1<71> b1<70> b1<69> b1<68> b1<67> b1<66> b1<65> b1<64> b1<63> b1<62>
+b1<61> b1<60> b1<59> b1<58> b1<57> b1<56> b1<55> b1<54> b1<53> b1<52> b1<51> b1<50> b1<49> b1<48> b1<47> b1<46> b1<45> b1<44> b1<43> b1<42> b1<41> b1<40> b1<39> b1<38> b1<37> b1<36> b1<35> b1<34> b1<33> b1<32> b1<31> b1<30> b1<29> b1<28> b1<27> b1<26> b1<25> b1<24> b1<23> b1<22> b1<21> b1<20> b1<19> b1<18> b1<17> b1<16> b1<15> b1<14> b1<13> b1<12> b1<11> b1<10> b1<9> b1<8> b1<7> b1<6> b1<5> b1<4> b1<3> b1<2> b1<1> b1<0> b<191> b<190> b<189> b<188> b<187> b<186> b<185> b<184> b<183> b<182> b<181> b<180> b<179> b<178> b<177> b<176> b<175> b<174> b<173> b<172> b<171> b<170> b<169> b<168> b<167> b<166> b<165> b<164> b<163> b<162> b<161> b<160> b<159> b<158> b<157> b<156> b<155> b<154> b<153> b<152> b<151> b<150> b<149> b<148> b<147> b<146> b<145> b<144> b<143> b<142> b<141> b<140> b<139> b<138> b<137> b<136> b<135> b<134> b<133> b<132> b<131> b<130> b<129> b<128> b<127> b<126> b<125> b<124> b<123> b<122> b<121> b<120> b<119> b<118> b<117> b<116> b<115> b<114> b<113> b<112> b<111> b<110> b<109> b<108> b<107>
+b<106> b<105> b<104> b<103> b<102> b<101> b<100> b<99> b<98> b<97> b<96> b<95> b<94> b<93> b<92> b<91> b<90> b<89> b<88> b<87> b<86> b<85> b<84> b<83> b<82> b<81> b<80> b<79> b<78> b<77> b<76> b<75> b<74> b<73> b<72> b<71> b<70> b<69> b<68> b<67> b<66> b<65> b<64> b<63> b<62> b<61> b<60> b<59> b<58> b<57> b<56> b<55> b<54> b<53> b<52> b<51> b<50> b<49> b<48> b<47> b<46> b<45> b<44> b<43> b<42> b<41> b<40> b<39> b<38> b<37> b<36> b<35> b<34> b<33> b<32> b<31> b<30> b<29> b<28> b<27> b<26> b<25> b<24> b<23> b<22> b<21> b<20> b<19> b<18> b<17> b<16> b<15> b<14> b<13> b<12> b<11> b<10> b<9> b<8> b<7> b<6> b<5> b<4> b<3> b<2> b<1> b<0>
xi100 w b1<63> b1<62> b1<61> b1<60> b1<59> b1<58> b1<57> b1<56> b1<55> b1<54> b1<53> b1<52> b1<51> b1<50> b1<49> b1<48> b1<47> b1<46> b1<45> b1<44> b1<43> b1<42> b1<41> b1<40> b1<39> b1<38> b1<37> b1<36> b1<35> b1<34> b1<33> b1<32> b1<31> b1<30> b1<29> b1<28> b1<27> b1<26> b1<25> b1<24> b1<23> b1<22> b1<21> b1<20> b1<19> b1<18> b1<17> b1<16> b1<15> b1<14> b1<13> b1<12> b1<11> b1<10> b1<9> b1<8> b1<7> b1<6> b1<5> b1<4> b1<3> b1<2> b1<1> b1<0> b<63> b<62> b<61> b<60> b<59> b<58> b<57> b<56> b<55> b<54> b<53> b<52> b<51> b<50> b<49> b<48> b<47> b<46> b<45> b<44> b<43> b<42> b<41> b<40> b<39> b<38> b<37> b<36> b<35> b<34> b<33> b<32> b<31> b<30> b<29> b<28> b<27> b<26> b<25> b<24> b<23> b<22> b<21> b<20> b<19> b<18> b<17> b<16> b<15> b<14> b<13> b<12> b<11> b<10> b<9> b<8> b<7> b<6> b<5> b<4> b<3> b<2> b<1> b<0> SRAM_64
xi37 w b1<127> b1<126> b1<125> b1<124> b1<123> b1<122> b1<121> b1<120> b1<119> b1<118> b1<117> b1<116> b1<115> b1<114> b1<113> b1<112> b1<111> b1<110> b1<109> b1<108> b1<107> b1<106> b1<105> b1<104> b1<103> b1<102> b1<101> b1<100> b1<99> b1<98> b1<97> b1<96> b1<95> b1<94> b1<93> b1<92> b1<91> b1<90> b1<89> b1<88> b1<87> b1<86> b1<85> b1<84> b1<83> b1<82> b1<81> b1<80> b1<79> b1<78> b1<77> b1<76> b1<75> b1<74> b1<73> b1<72> b1<71> b1<70> b1<69> b1<68> b1<67> b1<66> b1<65> b1<64> b<127> b<126> b<125> b<124> b<123> b<122> b<121> b<120> b<119> b<118> b<117> b<116> b<115> b<114> b<113> b<112> b<111> b<110> b<109> b<108> b<107> b<106> b<105> b<104> b<103> b<102> b<101> b<100> b<99> b<98> b<97> b<96> b<95> b<94> b<93> b<92> b<91> b<90> b<89> b<88> b<87> b<86> b<85> b<84> b<83> b<82> b<81> b<80> b<79> b<78> b<77> b<76> b<75> b<74> b<73> b<72> b<71> b<70> b<69> b<68> b<67> b<66> b<65> b<64> SRAM_64
xi5 w b1<191> b1<190> b1<189> b1<188> b1<187> b1<186> b1<185> b1<184> b1<183> b1<182> b1<181> b1<180> b1<179> b1<178> b1<177> b1<176> b1<175> b1<174> b1<173> b1<172> b1<171> b1<170> b1<169> b1<168> b1<167> b1<166> b1<165> b1<164> b1<163> b1<162> b1<161> b1<160> b1<159> b1<158> b1<157> b1<156> b1<155> b1<154> b1<153> b1<152> b1<151> b1<150> b1<149> b1<148> b1<147> b1<146> b1<145> b1<144> b1<143> b1<142> b1<141> b1<140> b1<139> b1<138> b1<137> b1<136> b1<135> b1<134> b1<133> b1<132> b1<131> b1<130> b1<129> b1<128> b<191> b<190> b<189> b<188> b<187> b<186> b<185> b<184> b<183> b<182> b<181> b<180> b<179> b<178> b<177> b<176> b<175> b<174> b<173> b<172> b<171> b<170> b<169> b<168> b<167> b<166> b<165> b<164> b<163> b<162> b<161> b<160> b<159> b<158> b<157> b<156> b<155> b<154> b<153> b<152> b<151> b<150> b<149> b<148> b<147> b<146> b<145> b<144> b<143> b<142> b<141> b<140> b<139> b<138> b<137> b<136> b<135> b<134> b<133> b<132> b<131> b<130> b<129> b<128> SRAM_64
.ends SRAM_192
** End of subcircuit definition.

** Library name: EE213CAN45nm
** Cell name: myinv45
** View name: schematic
.subckt myinv45 a z
m0 z a 0 0 NMOS_VTL L=50e-9 W=90e-9 AD=9.45e-15 AS=9.45e-15 PD=300e-9 PS=300e-9 M=1
m1 z a vdd! vdd! PMOS_VTL L=50e-9 W=180e-9 AD=9.45e-15 AS=9.45e-15 PD=300e-9 PS=300e-9 M=1
.ends myinv45
** End of subcircuit definition.

** Library name: EE213CAN45nm
** Cell name: write_driver
** View name: schematic
.subckt write_driver b b1 data_s1 write_en
m3 b1 net8 net011 0 NMOS_VTL L=50e-9 W=90e-9 AD=9.45e-15 AS=9.45e-15 PD=300e-9 PS=300e-9 M=1
m2 b data_s1 net012 net09 NMOS_VTL L=50e-9 W=90e-9 AD=9.45e-15 AS=9.45e-15 PD=300e-9 PS=300e-9 M=1
m5 net011 write_en 0 0 NMOS_VTL L=50e-9 W=90e-9 AD=9.45e-15 AS=9.45e-15 PD=300e-9 PS=300e-9 M=1
m4 net012 write_en 0 net09 NMOS_VTL L=50e-9 W=90e-9 AD=9.45e-15 AS=9.45e-15 PD=300e-9 PS=300e-9 M=1
xi0 data_s1 net8 myinv45
.ends write_driver
** End of subcircuit definition.

** Library name: EE213CAN45nm
** Cell name: write_driver_2
** View name: schematic
.subckt write_driver_2 b1<1> b1<0> b<1> b<0> data<1> data<0> write_en
xi1 b<0> b1<0> data<0> write_en write_driver
xi0 b<1> b1<1> data<1> write_en write_driver
.ends write_driver_2
** End of subcircuit definition.

** Library name: EE213CAN45nm
** Cell name: write_driver_4
** View name: schematic
.subckt write_driver_4 b1<3> b1<2> b1<1> b1<0> b<3> b<2> b<1> b<0> data<3> data<2> data<1> data<0> write_en
xi1 b1<1> b1<0> b<1> b<0> data<1> data<0> write_en write_driver_2
xi0 b1<3> b1<2> b<3> b<2> data<3> data<2> write_en write_driver_2
.ends write_driver_4
** End of subcircuit definition.

** Library name: EE213CAN45nm
** Cell name: write_driver_8
** View name: schematic
.subckt write_driver_8 b1<7> b1<6> b1<5> b1<4> b1<3> b1<2> b1<1> b1<0> b<7> b<6> b<5> b<4> b<3> b<2> b<1> b<0> data<7> data<6> data<5> data<4> data<3> data<2> data<1> data<0> write_en
xi1 b1<3> b1<2> b1<1> b1<0> b<3> b<2> b<1> b<0> data<3> data<2> data<1> data<0> write_en write_driver_4
xi0 b1<7> b1<6> b1<5> b1<4> b<7> b<6> b<5> b<4> data<7> data<6> data<5> data<4> write_en write_driver_4
.ends write_driver_8
** End of subcircuit definition.

** Library name: EE213CAN45nm
** Cell name: write_driver_16
** View name: schematic
.subckt write_driver_16 b1<15> b1<14> b1<13> b1<12> b1<11> b1<10> b1<9> b1<8> b1<7> b1<6> b1<5> b1<4> b1<3> b1<2> b1<1> b1<0> b<15> b<14> b<13> b<12> b<11> b<10> b<9> b<8> b<7> b<6> b<5> b<4> b<3> b<2> b<1> b<0> data<15> data<14> data<13> data<12> data<11> data<10> data<9> data<8> data<7> data<6> data<5> data<4> data<3> data<2> data<1> data<0> write_en
xi1 b1<7> b1<6> b1<5> b1<4> b1<3> b1<2> b1<1> b1<0> b<7> b<6> b<5> b<4> b<3> b<2> b<1> b<0> data<7> data<6> data<5> data<4> data<3> data<2> data<1> data<0> write_en write_driver_8
xi0 b1<15> b1<14> b1<13> b1<12> b1<11> b1<10> b1<9> b1<8> b<15> b<14> b<13> b<12> b<11> b<10> b<9> b<8> data<15> data<14> data<13> data<12> data<11> data<10> data<9> data<8> write_en write_driver_8
.ends write_driver_16
** End of subcircuit definition.

** Library name: EE213CAN45nm
** Cell name: write_driver_32
** View name: schematic
.subckt write_driver_32 b1<31> b1<30> b1<29> b1<28> b1<27> b1<26> b1<25> b1<24> b1<23> b1<22> b1<21> b1<20> b1<19> b1<18> b1<17> b1<16> b1<15> b1<14> b1<13> b1<12> b1<11> b1<10> b1<9> b1<8> b1<7> b1<6> b1<5> b1<4> b1<3> b1<2> b1<1> b1<0> b<31> b<30> b<29> b<28> b<27> b<26> b<25> b<24> b<23> b<22> b<21> b<20> b<19> b<18> b<17> b<16> b<15> b<14> b<13> b<12> b<11> b<10> b<9> b<8> b<7> b<6> b<5> b<4> b<3> b<2> b<1> b<0> data<31> data<30> data<29> data<28> data<27> data<26> data<25> data<24> data<23> data<22> data<21> data<20> data<19> data<18> data<17> data<16> data<15> data<14> data<13> data<12> data<11> data<10> data<9> data<8> data<7> data<6> data<5> data<4> data<3> data<2> data<1> data<0> write_en
xi1 b1<15> b1<14> b1<13> b1<12> b1<11> b1<10> b1<9> b1<8> b1<7> b1<6> b1<5> b1<4> b1<3> b1<2> b1<1> b1<0> b<15> b<14> b<13> b<12> b<11> b<10> b<9> b<8> b<7> b<6> b<5> b<4> b<3> b<2> b<1> b<0> data<15> data<14> data<13> data<12> data<11> data<10> data<9> data<8> data<7> data<6> data<5> data<4> data<3> data<2> data<1> data<0> write_en write_driver_16
xi0 b1<31> b1<30> b1<29> b1<28> b1<27> b1<26> b1<25> b1<24> b1<23> b1<22> b1<21> b1<20> b1<19> b1<18> b1<17> b1<16> b<31> b<30> b<29> b<28> b<27> b<26> b<25> b<24> b<23> b<22> b<21> b<20> b<19> b<18> b<17> b<16> data<31> data<30> data<29> data<28> data<27> data<26> data<25> data<24> data<23> data<22> data<21> data<20> data<19> data<18> data<17> data<16> write_en write_driver_16
.ends write_driver_32
** End of subcircuit definition.

** Library name: EE213CAN45nm
** Cell name: write_driver_64
** View name: schematic
.subckt write_driver_64 b1<63> b1<62> b1<61> b1<60> b1<59> b1<58> b1<57> b1<56> b1<55> b1<54> b1<53> b1<52> b1<51> b1<50> b1<49> b1<48> b1<47> b1<46> b1<45> b1<44> b1<43> b1<42> b1<41> b1<40> b1<39> b1<38> b1<37> b1<36> b1<35> b1<34> b1<33> b1<32> b1<31> b1<30> b1<29> b1<28> b1<27> b1<26> b1<25> b1<24> b1<23> b1<22> b1<21> b1<20> b1<19> b1<18> b1<17> b1<16> b1<15> b1<14> b1<13> b1<12> b1<11> b1<10> b1<9> b1<8> b1<7> b1<6> b1<5> b1<4> b1<3> b1<2> b1<1> b1<0> b<63> b<62> b<61> b<60> b<59> b<58> b<57> b<56> b<55> b<54> b<53> b<52> b<51> b<50> b<49> b<48> b<47> b<46> b<45> b<44> b<43> b<42> b<41> b<40> b<39> b<38> b<37> b<36> b<35> b<34> b<33> b<32> b<31> b<30> b<29> b<28> b<27> b<26> b<25> b<24> b<23> b<22> b<21> b<20> b<19> b<18> b<17> b<16> b<15> b<14> b<13> b<12> b<11> b<10> b<9> b<8> b<7> b<6> b<5> b<4> b<3> b<2> b<1> b<0> data<63> data<62> data<61> data<60> data<59> data<58> data<57> data<56> data<55> data<54> data<53> data<52> data<51> data<50> data<49> data<48> data<47> data<46> data<45> data<44>
+data<43> data<42> data<41> data<40> data<39> data<38> data<37> data<36> data<35> data<34> data<33> data<32> data<31> data<30> data<29> data<28> data<27> data<26> data<25> data<24> data<23> data<22> data<21> data<20> data<19> data<18> data<17> data<16> data<15> data<14> data<13> data<12> data<11> data<10> data<9> data<8> data<7> data<6> data<5> data<4> data<3> data<2> data<1> data<0> write_en
xi1 b1<31> b1<30> b1<29> b1<28> b1<27> b1<26> b1<25> b1<24> b1<23> b1<22> b1<21> b1<20> b1<19> b1<18> b1<17> b1<16> b1<15> b1<14> b1<13> b1<12> b1<11> b1<10> b1<9> b1<8> b1<7> b1<6> b1<5> b1<4> b1<3> b1<2> b1<1> b1<0> b<31> b<30> b<29> b<28> b<27> b<26> b<25> b<24> b<23> b<22> b<21> b<20> b<19> b<18> b<17> b<16> b<15> b<14> b<13> b<12> b<11> b<10> b<9> b<8> b<7> b<6> b<5> b<4> b<3> b<2> b<1> b<0> data<31> data<30> data<29> data<28> data<27> data<26> data<25> data<24> data<23> data<22> data<21> data<20> data<19> data<18> data<17> data<16> data<15> data<14> data<13> data<12> data<11> data<10> data<9> data<8> data<7> data<6> data<5> data<4> data<3> data<2> data<1> data<0> write_en write_driver_32
xi0 b1<63> b1<62> b1<61> b1<60> b1<59> b1<58> b1<57> b1<56> b1<55> b1<54> b1<53> b1<52> b1<51> b1<50> b1<49> b1<48> b1<47> b1<46> b1<45> b1<44> b1<43> b1<42> b1<41> b1<40> b1<39> b1<38> b1<37> b1<36> b1<35> b1<34> b1<33> b1<32> b<63> b<62> b<61> b<60> b<59> b<58> b<57> b<56> b<55> b<54> b<53> b<52> b<51> b<50> b<49> b<48> b<47> b<46> b<45> b<44> b<43> b<42> b<41> b<40> b<39> b<38> b<37> b<36> b<35> b<34> b<33> b<32> data<63> data<62> data<61> data<60> data<59> data<58> data<57> data<56> data<55> data<54> data<53> data<52> data<51> data<50> data<49> data<48> data<47> data<46> data<45> data<44> data<43> data<42> data<41> data<40> data<39> data<38> data<37> data<36> data<35> data<34> data<33> data<32> write_en write_driver_32
.ends write_driver_64
** End of subcircuit definition.

** Library name: EE213CAN45nm
** Cell name: write_driver_192
** View name: schematic
.subckt write_driver_192 b1<191> b1<190> b1<189> b1<188> b1<187> b1<186> b1<185> b1<184> b1<183> b1<182> b1<181> b1<180> b1<179> b1<178> b1<177> b1<176> b1<175> b1<174> b1<173> b1<172> b1<171> b1<170> b1<169> b1<168> b1<167> b1<166> b1<165> b1<164> b1<163> b1<162> b1<161> b1<160> b1<159> b1<158> b1<157> b1<156> b1<155> b1<154> b1<153> b1<152> b1<151> b1<150> b1<149> b1<148> b1<147> b1<146> b1<145> b1<144> b1<143> b1<142> b1<141> b1<140> b1<139> b1<138> b1<137> b1<136> b1<135> b1<134> b1<133> b1<132> b1<131> b1<130> b1<129> b1<128> b1<127> b1<126> b1<125> b1<124> b1<123> b1<122> b1<121> b1<120> b1<119> b1<118> b1<117> b1<116> b1<115> b1<114> b1<113> b1<112> b1<111> b1<110> b1<109> b1<108> b1<107> b1<106> b1<105> b1<104> b1<103> b1<102> b1<101> b1<100> b1<99> b1<98> b1<97> b1<96> b1<95> b1<94> b1<93> b1<92> b1<91> b1<90> b1<89> b1<88> b1<87> b1<86> b1<85> b1<84> b1<83> b1<82> b1<81> b1<80> b1<79> b1<78> b1<77> b1<76> b1<75> b1<74> b1<73> b1<72> b1<71> b1<70> b1<69> b1<68> b1<67> b1<66> b1<65> b1<64> b1<63>
+b1<62> b1<61> b1<60> b1<59> b1<58> b1<57> b1<56> b1<55> b1<54> b1<53> b1<52> b1<51> b1<50> b1<49> b1<48> b1<47> b1<46> b1<45> b1<44> b1<43> b1<42> b1<41> b1<40> b1<39> b1<38> b1<37> b1<36> b1<35> b1<34> b1<33> b1<32> b1<31> b1<30> b1<29> b1<28> b1<27> b1<26> b1<25> b1<24> b1<23> b1<22> b1<21> b1<20> b1<19> b1<18> b1<17> b1<16> b1<15> b1<14> b1<13> b1<12> b1<11> b1<10> b1<9> b1<8> b1<7> b1<6> b1<5> b1<4> b1<3> b1<2> b1<1> b1<0> b<191> b<190> b<189> b<188> b<187> b<186> b<185> b<184> b<183> b<182> b<181> b<180> b<179> b<178> b<177> b<176> b<175> b<174> b<173> b<172> b<171> b<170> b<169> b<168> b<167> b<166> b<165> b<164> b<163> b<162> b<161> b<160> b<159> b<158> b<157> b<156> b<155> b<154> b<153> b<152> b<151> b<150> b<149> b<148> b<147> b<146> b<145> b<144> b<143> b<142> b<141> b<140> b<139> b<138> b<137> b<136> b<135> b<134> b<133> b<132> b<131> b<130> b<129> b<128> b<127> b<126> b<125> b<124> b<123> b<122> b<121> b<120> b<119> b<118> b<117> b<116> b<115> b<114> b<113> b<112> b<111> b<110> b<109> b<108>
+b<107> b<106> b<105> b<104> b<103> b<102> b<101> b<100> b<99> b<98> b<97> b<96> b<95> b<94> b<93> b<92> b<91> b<90> b<89> b<88> b<87> b<86> b<85> b<84> b<83> b<82> b<81> b<80> b<79> b<78> b<77> b<76> b<75> b<74> b<73> b<72> b<71> b<70> b<69> b<68> b<67> b<66> b<65> b<64> b<63> b<62> b<61> b<60> b<59> b<58> b<57> b<56> b<55> b<54> b<53> b<52> b<51> b<50> b<49> b<48> b<47> b<46> b<45> b<44> b<43> b<42> b<41> b<40> b<39> b<38> b<37> b<36> b<35> b<34> b<33> b<32> b<31> b<30> b<29> b<28> b<27> b<26> b<25> b<24> b<23> b<22> b<21> b<20> b<19> b<18> b<17> b<16> b<15> b<14> b<13> b<12> b<11> b<10> b<9> b<8> b<7> b<6> b<5> b<4> b<3> b<2> b<1> b<0> data<191> data<190> data<189> data<188> data<187> data<186> data<185> data<184> data<183> data<182> data<181> data<180> data<179> data<178> data<177> data<176> data<175> data<174> data<173> data<172> data<171> data<170> data<169> data<168> data<167> data<166> data<165> data<164> data<163> data<162> data<161> data<160> data<159> data<158> data<157> data<156> data<155>
+data<154> data<153> data<152> data<151> data<150> data<149> data<148> data<147> data<146> data<145> data<144> data<143> data<142> data<141> data<140> data<139> data<138> data<137> data<136> data<135> data<134> data<133> data<132> data<131> data<130> data<129> data<128> data<127> data<126> data<125> data<124> data<123> data<122> data<121> data<120> data<119> data<118> data<117> data<116> data<115> data<114> data<113> data<112> data<111> data<110> data<109> data<108> data<107> data<106> data<105> data<104> data<103> data<102> data<101> data<100> data<99> data<98> data<97> data<96> data<95> data<94> data<93> data<92> data<91> data<90> data<89> data<88> data<87> data<86> data<85> data<84> data<83> data<82> data<81> data<80> data<79> data<78> data<77> data<76> data<75> data<74> data<73> data<72> data<71> data<70> data<69> data<68> data<67> data<66> data<65> data<64> data<63> data<62> data<61> data<60> data<59> data<58> data<57> data<56> data<55> data<54> data<53> data<52> data<51> data<50> data<49> data<48>
+data<47> data<46> data<45> data<44> data<43> data<42> data<41> data<40> data<39> data<38> data<37> data<36> data<35> data<34> data<33> data<32> data<31> data<30> data<29> data<28> data<27> data<26> data<25> data<24> data<23> data<22> data<21> data<20> data<19> data<18> data<17> data<16> data<15> data<14> data<13> data<12> data<11> data<10> data<9> data<8> data<7> data<6> data<5> data<4> data<3> data<2> data<1> data<0> write_en
xi2 b1<63> b1<62> b1<61> b1<60> b1<59> b1<58> b1<57> b1<56> b1<55> b1<54> b1<53> b1<52> b1<51> b1<50> b1<49> b1<48> b1<47> b1<46> b1<45> b1<44> b1<43> b1<42> b1<41> b1<40> b1<39> b1<38> b1<37> b1<36> b1<35> b1<34> b1<33> b1<32> b1<31> b1<30> b1<29> b1<28> b1<27> b1<26> b1<25> b1<24> b1<23> b1<22> b1<21> b1<20> b1<19> b1<18> b1<17> b1<16> b1<15> b1<14> b1<13> b1<12> b1<11> b1<10> b1<9> b1<8> b1<7> b1<6> b1<5> b1<4> b1<3> b1<2> b1<1> b1<0> b<63> b<62> b<61> b<60> b<59> b<58> b<57> b<56> b<55> b<54> b<53> b<52> b<51> b<50> b<49> b<48> b<47> b<46> b<45> b<44> b<43> b<42> b<41> b<40> b<39> b<38> b<37> b<36> b<35> b<34> b<33> b<32> b<31> b<30> b<29> b<28> b<27> b<26> b<25> b<24> b<23> b<22> b<21> b<20> b<19> b<18> b<17> b<16> b<15> b<14> b<13> b<12> b<11> b<10> b<9> b<8> b<7> b<6> b<5> b<4> b<3> b<2> b<1> b<0> data<63> data<62> data<61> data<60> data<59> data<58> data<57> data<56> data<55> data<54> data<53> data<52> data<51> data<50> data<49> data<48> data<47> data<46> data<45> data<44> data<43> data<42> data<41>
+data<40> data<39> data<38> data<37> data<36> data<35> data<34> data<33> data<32> data<31> data<30> data<29> data<28> data<27> data<26> data<25> data<24> data<23> data<22> data<21> data<20> data<19> data<18> data<17> data<16> data<15> data<14> data<13> data<12> data<11> data<10> data<9> data<8> data<7> data<6> data<5> data<4> data<3> data<2> data<1> data<0> write_en write_driver_64
xi1 b1<127> b1<126> b1<125> b1<124> b1<123> b1<122> b1<121> b1<120> b1<119> b1<118> b1<117> b1<116> b1<115> b1<114> b1<113> b1<112> b1<111> b1<110> b1<109> b1<108> b1<107> b1<106> b1<105> b1<104> b1<103> b1<102> b1<101> b1<100> b1<99> b1<98> b1<97> b1<96> b1<95> b1<94> b1<93> b1<92> b1<91> b1<90> b1<89> b1<88> b1<87> b1<86> b1<85> b1<84> b1<83> b1<82> b1<81> b1<80> b1<79> b1<78> b1<77> b1<76> b1<75> b1<74> b1<73> b1<72> b1<71> b1<70> b1<69> b1<68> b1<67> b1<66> b1<65> b1<64> b<127> b<126> b<125> b<124> b<123> b<122> b<121> b<120> b<119> b<118> b<117> b<116> b<115> b<114> b<113> b<112> b<111> b<110> b<109> b<108> b<107> b<106> b<105> b<104> b<103> b<102> b<101> b<100> b<99> b<98> b<97> b<96> b<95> b<94> b<93> b<92> b<91> b<90> b<89> b<88> b<87> b<86> b<85> b<84> b<83> b<82> b<81> b<80> b<79> b<78> b<77> b<76> b<75> b<74> b<73> b<72> b<71> b<70> b<69> b<68> b<67> b<66> b<65> b<64> data<127> data<126> data<125> data<124> data<123> data<122> data<121> data<120> data<119> data<118> data<117> data<116> data<115>
+data<114> data<113> data<112> data<111> data<110> data<109> data<108> data<107> data<106> data<105> data<104> data<103> data<102> data<101> data<100> data<99> data<98> data<97> data<96> data<95> data<94> data<93> data<92> data<91> data<90> data<89> data<88> data<87> data<86> data<85> data<84> data<83> data<82> data<81> data<80> data<79> data<78> data<77> data<76> data<75> data<74> data<73> data<72> data<71> data<70> data<69> data<68> data<67> data<66> data<65> data<64> write_en write_driver_64
xi0 b1<191> b1<190> b1<189> b1<188> b1<187> b1<186> b1<185> b1<184> b1<183> b1<182> b1<181> b1<180> b1<179> b1<178> b1<177> b1<176> b1<175> b1<174> b1<173> b1<172> b1<171> b1<170> b1<169> b1<168> b1<167> b1<166> b1<165> b1<164> b1<163> b1<162> b1<161> b1<160> b1<159> b1<158> b1<157> b1<156> b1<155> b1<154> b1<153> b1<152> b1<151> b1<150> b1<149> b1<148> b1<147> b1<146> b1<145> b1<144> b1<143> b1<142> b1<141> b1<140> b1<139> b1<138> b1<137> b1<136> b1<135> b1<134> b1<133> b1<132> b1<131> b1<130> b1<129> b1<128> b<191> b<190> b<189> b<188> b<187> b<186> b<185> b<184> b<183> b<182> b<181> b<180> b<179> b<178> b<177> b<176> b<175> b<174> b<173> b<172> b<171> b<170> b<169> b<168> b<167> b<166> b<165> b<164> b<163> b<162> b<161> b<160> b<159> b<158> b<157> b<156> b<155> b<154> b<153> b<152> b<151> b<150> b<149> b<148> b<147> b<146> b<145> b<144> b<143> b<142> b<141> b<140> b<139> b<138> b<137> b<136> b<135> b<134> b<133> b<132> b<131> b<130> b<129> b<128> data<191> data<190> data<189> data<188> data<187> data<186>
+data<185> data<184> data<183> data<182> data<181> data<180> data<179> data<178> data<177> data<176> data<175> data<174> data<173> data<172> data<171> data<170> data<169> data<168> data<167> data<166> data<165> data<164> data<163> data<162> data<161> data<160> data<159> data<158> data<157> data<156> data<155> data<154> data<153> data<152> data<151> data<150> data<149> data<148> data<147> data<146> data<145> data<144> data<143> data<142> data<141> data<140> data<139> data<138> data<137> data<136> data<135> data<134> data<133> data<132> data<131> data<130> data<129> data<128> write_en write_driver_64
.ends write_driver_192
** End of subcircuit definition.

** Library name: EE213CAN45nm
** Cell name: SAdiff
** View name: schematic
.subckt SAdiff b b1 en sense sense_b
m1 sense b1 net14 0 NMOS_VTL L=50e-9 W=90e-9 AD=9.45e-15 AS=9.45e-15 PD=300e-9 PS=300e-9 M=1
m0 sense_b b net14 0 NMOS_VTL L=50e-9 W=90e-9 AD=9.45e-15 AS=9.45e-15 PD=300e-9 PS=300e-9 M=1
m5 net17 en 0 0 NMOS_VTL L=50e-9 W=90e-9 AD=9.45e-15 AS=9.45e-15 PD=300e-9 PS=300e-9 M=1
m2 net14 vdd! net17 0 NMOS_VTL L=50e-9 W=90e-9 AD=9.45e-15 AS=9.45e-15 PD=300e-9 PS=300e-9 M=1
m4 sense_b sense_b vdd! vdd! PMOS_VTL L=50e-9 W=180e-9 AD=9.45e-15 AS=9.45e-15 PD=300e-9 PS=300e-9 M=1
m3 sense sense_b vdd! vdd! PMOS_VTL L=50e-9 W=180e-9 AD=9.45e-15 AS=9.45e-15 PD=300e-9 PS=300e-9 M=1
.ends SAdiff
** End of subcircuit definition.

** Library name: EE213CAN45nm
** Cell name: SAdiff_2
** View name: schematic
.subckt SAdiff_2 b1<1> b1<0> b<1> b<0> en sense<1> sense<0> sense_b<1> sense_b<0>
xi1 b<0> b1<0> en sense<0> sense_b<0> SAdiff
xi0 b<1> b1<1> en sense<1> sense_b<1> SAdiff
.ends SAdiff_2
** End of subcircuit definition.

** Library name: EE213CAN45nm
** Cell name: SAdiff_4
** View name: schematic
.subckt SAdiff_4 b1<3> b1<2> b1<1> b1<0> b<3> b<2> b<1> b<0> en sense<3> sense<2> sense<1> sense<0> sense_b<3> sense_b<2> sense_b<1> sense_b<0>
xi1 b1<1> b1<0> b<1> b<0> en sense<1> sense<0> sense_b<1> sense_b<0> SAdiff_2
xi0 b1<3> b1<2> b<3> b<2> en sense<3> sense<2> sense_b<3> sense_b<2> SAdiff_2
.ends SAdiff_4
** End of subcircuit definition.

** Library name: EE213CAN45nm
** Cell name: SAdiff_8
** View name: schematic
.subckt SAdiff_8 b1<7> b1<6> b1<5> b1<4> b1<3> b1<2> b1<1> b1<0> b<7> b<6> b<5> b<4> b<3> b<2> b<1> b<0> en sense<7> sense<6> sense<5> sense<4> sense<3> sense<2> sense<1> sense<0> sense_b<7> sense_b<6> sense_b<5> sense_b<4> sense_b<3> sense_b<2> sense_b<1> sense_b<0>
xi1 b1<3> b1<2> b1<1> b1<0> b<3> b<2> b<1> b<0> en sense<3> sense<2> sense<1> sense<0> sense_b<3> sense_b<2> sense_b<1> sense_b<0> SAdiff_4
xi0 b1<7> b1<6> b1<5> b1<4> b<7> b<6> b<5> b<4> en sense<7> sense<6> sense<5> sense<4> sense_b<7> sense_b<6> sense_b<5> sense_b<4> SAdiff_4
.ends SAdiff_8
** End of subcircuit definition.

** Library name: EE213CAN45nm
** Cell name: SAdiff_16
** View name: schematic
.subckt SAdiff_16 b1<15> b1<14> b1<13> b1<12> b1<11> b1<10> b1<9> b1<8> b1<7> b1<6> b1<5> b1<4> b1<3> b1<2> b1<1> b1<0> b<15> b<14> b<13> b<12> b<11> b<10> b<9> b<8> b<7> b<6> b<5> b<4> b<3> b<2> b<1> b<0> en sense<15> sense<14> sense<13> sense<12> sense<11> sense<10> sense<9> sense<8> sense<7> sense<6> sense<5> sense<4> sense<3> sense<2> sense<1> sense<0> sense_b<15> sense_b<14> sense_b<13> sense_b<12> sense_b<11> sense_b<10> sense_b<9> sense_b<8> sense_b<7> sense_b<6> sense_b<5> sense_b<4> sense_b<3> sense_b<2> sense_b<1> sense_b<0>
xi1 b1<7> b1<6> b1<5> b1<4> b1<3> b1<2> b1<1> b1<0> b<7> b<6> b<5> b<4> b<3> b<2> b<1> b<0> en sense<7> sense<6> sense<5> sense<4> sense<3> sense<2> sense<1> sense<0> sense_b<7> sense_b<6> sense_b<5> sense_b<4> sense_b<3> sense_b<2> sense_b<1> sense_b<0> SAdiff_8
xi0 b1<15> b1<14> b1<13> b1<12> b1<11> b1<10> b1<9> b1<8> b<15> b<14> b<13> b<12> b<11> b<10> b<9> b<8> en sense<15> sense<14> sense<13> sense<12> sense<11> sense<10> sense<9> sense<8> sense_b<15> sense_b<14> sense_b<13> sense_b<12> sense_b<11> sense_b<10> sense_b<9> sense_b<8> SAdiff_8
.ends SAdiff_16
** End of subcircuit definition.

** Library name: EE213CAN45nm
** Cell name: SAdiff_32
** View name: schematic
.subckt SAdiff_32 b1<31> b1<30> b1<29> b1<28> b1<27> b1<26> b1<25> b1<24> b1<23> b1<22> b1<21> b1<20> b1<19> b1<18> b1<17> b1<16> b1<15> b1<14> b1<13> b1<12> b1<11> b1<10> b1<9> b1<8> b1<7> b1<6> b1<5> b1<4> b1<3> b1<2> b1<1> b1<0> b<31> b<30> b<29> b<28> b<27> b<26> b<25> b<24> b<23> b<22> b<21> b<20> b<19> b<18> b<17> b<16> b<15> b<14> b<13> b<12> b<11> b<10> b<9> b<8> b<7> b<6> b<5> b<4> b<3> b<2> b<1> b<0> en sense<31> sense<30> sense<29> sense<28> sense<27> sense<26> sense<25> sense<24> sense<23> sense<22> sense<21> sense<20> sense<19> sense<18> sense<17> sense<16> sense<15> sense<14> sense<13> sense<12> sense<11> sense<10> sense<9> sense<8> sense<7> sense<6> sense<5> sense<4> sense<3> sense<2> sense<1> sense<0> sense_b<31> sense_b<30> sense_b<29> sense_b<28> sense_b<27> sense_b<26> sense_b<25> sense_b<24> sense_b<23> sense_b<22> sense_b<21> sense_b<20> sense_b<19> sense_b<18> sense_b<17> sense_b<16> sense_b<15> sense_b<14> sense_b<13> sense_b<12> sense_b<11> sense_b<10> sense_b<9> sense_b<8> sense_b<7>
+sense_b<6> sense_b<5> sense_b<4> sense_b<3> sense_b<2> sense_b<1> sense_b<0>
xi1 b1<15> b1<14> b1<13> b1<12> b1<11> b1<10> b1<9> b1<8> b1<7> b1<6> b1<5> b1<4> b1<3> b1<2> b1<1> b1<0> b<15> b<14> b<13> b<12> b<11> b<10> b<9> b<8> b<7> b<6> b<5> b<4> b<3> b<2> b<1> b<0> en sense<15> sense<14> sense<13> sense<12> sense<11> sense<10> sense<9> sense<8> sense<7> sense<6> sense<5> sense<4> sense<3> sense<2> sense<1> sense<0> sense_b<15> sense_b<14> sense_b<13> sense_b<12> sense_b<11> sense_b<10> sense_b<9> sense_b<8> sense_b<7> sense_b<6> sense_b<5> sense_b<4> sense_b<3> sense_b<2> sense_b<1> sense_b<0> SAdiff_16
xi0 b1<31> b1<30> b1<29> b1<28> b1<27> b1<26> b1<25> b1<24> b1<23> b1<22> b1<21> b1<20> b1<19> b1<18> b1<17> b1<16> b<31> b<30> b<29> b<28> b<27> b<26> b<25> b<24> b<23> b<22> b<21> b<20> b<19> b<18> b<17> b<16> en sense<31> sense<30> sense<29> sense<28> sense<27> sense<26> sense<25> sense<24> sense<23> sense<22> sense<21> sense<20> sense<19> sense<18> sense<17> sense<16> sense_b<31> sense_b<30> sense_b<29> sense_b<28> sense_b<27> sense_b<26> sense_b<25> sense_b<24> sense_b<23> sense_b<22> sense_b<21> sense_b<20> sense_b<19> sense_b<18> sense_b<17> sense_b<16> SAdiff_16
.ends SAdiff_32
** End of subcircuit definition.

** Library name: EE213CAN45nm
** Cell name: SAdiff_64
** View name: schematic
.subckt SAdiff_64 b1<63> b1<62> b1<61> b1<60> b1<59> b1<58> b1<57> b1<56> b1<55> b1<54> b1<53> b1<52> b1<51> b1<50> b1<49> b1<48> b1<47> b1<46> b1<45> b1<44> b1<43> b1<42> b1<41> b1<40> b1<39> b1<38> b1<37> b1<36> b1<35> b1<34> b1<33> b1<32> b1<31> b1<30> b1<29> b1<28> b1<27> b1<26> b1<25> b1<24> b1<23> b1<22> b1<21> b1<20> b1<19> b1<18> b1<17> b1<16> b1<15> b1<14> b1<13> b1<12> b1<11> b1<10> b1<9> b1<8> b1<7> b1<6> b1<5> b1<4> b1<3> b1<2> b1<1> b1<0> b<63> b<62> b<61> b<60> b<59> b<58> b<57> b<56> b<55> b<54> b<53> b<52> b<51> b<50> b<49> b<48> b<47> b<46> b<45> b<44> b<43> b<42> b<41> b<40> b<39> b<38> b<37> b<36> b<35> b<34> b<33> b<32> b<31> b<30> b<29> b<28> b<27> b<26> b<25> b<24> b<23> b<22> b<21> b<20> b<19> b<18> b<17> b<16> b<15> b<14> b<13> b<12> b<11> b<10> b<9> b<8> b<7> b<6> b<5> b<4> b<3> b<2> b<1> b<0> en sense<63> sense<62> sense<61> sense<60> sense<59> sense<58> sense<57> sense<56> sense<55> sense<54> sense<53> sense<52> sense<51> sense<50> sense<49> sense<48> sense<47> sense<46> sense<45>
+sense<44> sense<43> sense<42> sense<41> sense<40> sense<39> sense<38> sense<37> sense<36> sense<35> sense<34> sense<33> sense<32> sense<31> sense<30> sense<29> sense<28> sense<27> sense<26> sense<25> sense<24> sense<23> sense<22> sense<21> sense<20> sense<19> sense<18> sense<17> sense<16> sense<15> sense<14> sense<13> sense<12> sense<11> sense<10> sense<9> sense<8> sense<7> sense<6> sense<5> sense<4> sense<3> sense<2> sense<1> sense<0> sense_b<63> sense_b<62> sense_b<61> sense_b<60> sense_b<59> sense_b<58> sense_b<57> sense_b<56> sense_b<55> sense_b<54> sense_b<53> sense_b<52> sense_b<51> sense_b<50> sense_b<49> sense_b<48> sense_b<47> sense_b<46> sense_b<45> sense_b<44> sense_b<43> sense_b<42> sense_b<41> sense_b<40> sense_b<39> sense_b<38> sense_b<37> sense_b<36> sense_b<35> sense_b<34> sense_b<33> sense_b<32> sense_b<31> sense_b<30> sense_b<29> sense_b<28> sense_b<27> sense_b<26> sense_b<25> sense_b<24> sense_b<23> sense_b<22> sense_b<21> sense_b<20> sense_b<19> sense_b<18> sense_b<17> sense_b<16>
+sense_b<15> sense_b<14> sense_b<13> sense_b<12> sense_b<11> sense_b<10> sense_b<9> sense_b<8> sense_b<7> sense_b<6> sense_b<5> sense_b<4> sense_b<3> sense_b<2> sense_b<1> sense_b<0>
xi1 b1<31> b1<30> b1<29> b1<28> b1<27> b1<26> b1<25> b1<24> b1<23> b1<22> b1<21> b1<20> b1<19> b1<18> b1<17> b1<16> b1<15> b1<14> b1<13> b1<12> b1<11> b1<10> b1<9> b1<8> b1<7> b1<6> b1<5> b1<4> b1<3> b1<2> b1<1> b1<0> b<31> b<30> b<29> b<28> b<27> b<26> b<25> b<24> b<23> b<22> b<21> b<20> b<19> b<18> b<17> b<16> b<15> b<14> b<13> b<12> b<11> b<10> b<9> b<8> b<7> b<6> b<5> b<4> b<3> b<2> b<1> b<0> en sense<31> sense<30> sense<29> sense<28> sense<27> sense<26> sense<25> sense<24> sense<23> sense<22> sense<21> sense<20> sense<19> sense<18> sense<17> sense<16> sense<15> sense<14> sense<13> sense<12> sense<11> sense<10> sense<9> sense<8> sense<7> sense<6> sense<5> sense<4> sense<3> sense<2> sense<1> sense<0> sense_b<31> sense_b<30> sense_b<29> sense_b<28> sense_b<27> sense_b<26> sense_b<25> sense_b<24> sense_b<23> sense_b<22> sense_b<21> sense_b<20> sense_b<19> sense_b<18> sense_b<17> sense_b<16> sense_b<15> sense_b<14> sense_b<13> sense_b<12> sense_b<11> sense_b<10> sense_b<9> sense_b<8> sense_b<7> sense_b<6>
+sense_b<5> sense_b<4> sense_b<3> sense_b<2> sense_b<1> sense_b<0> SAdiff_32
xi0 b1<63> b1<62> b1<61> b1<60> b1<59> b1<58> b1<57> b1<56> b1<55> b1<54> b1<53> b1<52> b1<51> b1<50> b1<49> b1<48> b1<47> b1<46> b1<45> b1<44> b1<43> b1<42> b1<41> b1<40> b1<39> b1<38> b1<37> b1<36> b1<35> b1<34> b1<33> b1<32> b<63> b<62> b<61> b<60> b<59> b<58> b<57> b<56> b<55> b<54> b<53> b<52> b<51> b<50> b<49> b<48> b<47> b<46> b<45> b<44> b<43> b<42> b<41> b<40> b<39> b<38> b<37> b<36> b<35> b<34> b<33> b<32> en sense<63> sense<62> sense<61> sense<60> sense<59> sense<58> sense<57> sense<56> sense<55> sense<54> sense<53> sense<52> sense<51> sense<50> sense<49> sense<48> sense<47> sense<46> sense<45> sense<44> sense<43> sense<42> sense<41> sense<40> sense<39> sense<38> sense<37> sense<36> sense<35> sense<34> sense<33> sense<32> sense_b<63> sense_b<62> sense_b<61> sense_b<60> sense_b<59> sense_b<58> sense_b<57> sense_b<56> sense_b<55> sense_b<54> sense_b<53> sense_b<52> sense_b<51> sense_b<50> sense_b<49> sense_b<48> sense_b<47> sense_b<46> sense_b<45> sense_b<44> sense_b<43> sense_b<42> sense_b<41>
+sense_b<40> sense_b<39> sense_b<38> sense_b<37> sense_b<36> sense_b<35> sense_b<34> sense_b<33> sense_b<32> SAdiff_32
.ends SAdiff_64
** End of subcircuit definition.

** Library name: EE213CAN45nm
** Cell name: SAdiff_192
** View name: schematic
.subckt SAdiff_192 b1<191> b1<190> b1<189> b1<188> b1<187> b1<186> b1<185> b1<184> b1<183> b1<182> b1<181> b1<180> b1<179> b1<178> b1<177> b1<176> b1<175> b1<174> b1<173> b1<172> b1<171> b1<170> b1<169> b1<168> b1<167> b1<166> b1<165> b1<164> b1<163> b1<162> b1<161> b1<160> b1<159> b1<158> b1<157> b1<156> b1<155> b1<154> b1<153> b1<152> b1<151> b1<150> b1<149> b1<148> b1<147> b1<146> b1<145> b1<144> b1<143> b1<142> b1<141> b1<140> b1<139> b1<138> b1<137> b1<136> b1<135> b1<134> b1<133> b1<132> b1<131> b1<130> b1<129> b1<128> b1<127> b1<126> b1<125> b1<124> b1<123> b1<122> b1<121> b1<120> b1<119> b1<118> b1<117> b1<116> b1<115> b1<114> b1<113> b1<112> b1<111> b1<110> b1<109> b1<108> b1<107> b1<106> b1<105> b1<104> b1<103> b1<102> b1<101> b1<100> b1<99> b1<98> b1<97> b1<96> b1<95> b1<94> b1<93> b1<92> b1<91> b1<90> b1<89> b1<88> b1<87> b1<86> b1<85> b1<84> b1<83> b1<82> b1<81> b1<80> b1<79> b1<78> b1<77> b1<76> b1<75> b1<74> b1<73> b1<72> b1<71> b1<70> b1<69> b1<68> b1<67> b1<66> b1<65> b1<64> b1<63> b1<62>
+b1<61> b1<60> b1<59> b1<58> b1<57> b1<56> b1<55> b1<54> b1<53> b1<52> b1<51> b1<50> b1<49> b1<48> b1<47> b1<46> b1<45> b1<44> b1<43> b1<42> b1<41> b1<40> b1<39> b1<38> b1<37> b1<36> b1<35> b1<34> b1<33> b1<32> b1<31> b1<30> b1<29> b1<28> b1<27> b1<26> b1<25> b1<24> b1<23> b1<22> b1<21> b1<20> b1<19> b1<18> b1<17> b1<16> b1<15> b1<14> b1<13> b1<12> b1<11> b1<10> b1<9> b1<8> b1<7> b1<6> b1<5> b1<4> b1<3> b1<2> b1<1> b1<0> b<191> b<190> b<189> b<188> b<187> b<186> b<185> b<184> b<183> b<182> b<181> b<180> b<179> b<178> b<177> b<176> b<175> b<174> b<173> b<172> b<171> b<170> b<169> b<168> b<167> b<166> b<165> b<164> b<163> b<162> b<161> b<160> b<159> b<158> b<157> b<156> b<155> b<154> b<153> b<152> b<151> b<150> b<149> b<148> b<147> b<146> b<145> b<144> b<143> b<142> b<141> b<140> b<139> b<138> b<137> b<136> b<135> b<134> b<133> b<132> b<131> b<130> b<129> b<128> b<127> b<126> b<125> b<124> b<123> b<122> b<121> b<120> b<119> b<118> b<117> b<116> b<115> b<114> b<113> b<112> b<111> b<110> b<109> b<108> b<107>
+b<106> b<105> b<104> b<103> b<102> b<101> b<100> b<99> b<98> b<97> b<96> b<95> b<94> b<93> b<92> b<91> b<90> b<89> b<88> b<87> b<86> b<85> b<84> b<83> b<82> b<81> b<80> b<79> b<78> b<77> b<76> b<75> b<74> b<73> b<72> b<71> b<70> b<69> b<68> b<67> b<66> b<65> b<64> b<63> b<62> b<61> b<60> b<59> b<58> b<57> b<56> b<55> b<54> b<53> b<52> b<51> b<50> b<49> b<48> b<47> b<46> b<45> b<44> b<43> b<42> b<41> b<40> b<39> b<38> b<37> b<36> b<35> b<34> b<33> b<32> b<31> b<30> b<29> b<28> b<27> b<26> b<25> b<24> b<23> b<22> b<21> b<20> b<19> b<18> b<17> b<16> b<15> b<14> b<13> b<12> b<11> b<10> b<9> b<8> b<7> b<6> b<5> b<4> b<3> b<2> b<1> b<0> en sense<191> sense<190> sense<189> sense<188> sense<187> sense<186> sense<185> sense<184> sense<183> sense<182> sense<181> sense<180> sense<179> sense<178> sense<177> sense<176> sense<175> sense<174> sense<173> sense<172> sense<171> sense<170> sense<169> sense<168> sense<167> sense<166> sense<165> sense<164> sense<163> sense<162> sense<161> sense<160> sense<159> sense<158>
+sense<157> sense<156> sense<155> sense<154> sense<153> sense<152> sense<151> sense<150> sense<149> sense<148> sense<147> sense<146> sense<145> sense<144> sense<143> sense<142> sense<141> sense<140> sense<139> sense<138> sense<137> sense<136> sense<135> sense<134> sense<133> sense<132> sense<131> sense<130> sense<129> sense<128> sense<127> sense<126> sense<125> sense<124> sense<123> sense<122> sense<121> sense<120> sense<119> sense<118> sense<117> sense<116> sense<115> sense<114> sense<113> sense<112> sense<111> sense<110> sense<109> sense<108> sense<107> sense<106> sense<105> sense<104> sense<103> sense<102> sense<101> sense<100> sense<99> sense<98> sense<97> sense<96> sense<95> sense<94> sense<93> sense<92> sense<91> sense<90> sense<89> sense<88> sense<87> sense<86> sense<85> sense<84> sense<83> sense<82> sense<81> sense<80> sense<79> sense<78> sense<77> sense<76> sense<75> sense<74> sense<73> sense<72> sense<71> sense<70> sense<69> sense<68> sense<67> sense<66> sense<65> sense<64> sense<63> sense<62>
+sense<61> sense<60> sense<59> sense<58> sense<57> sense<56> sense<55> sense<54> sense<53> sense<52> sense<51> sense<50> sense<49> sense<48> sense<47> sense<46> sense<45> sense<44> sense<43> sense<42> sense<41> sense<40> sense<39> sense<38> sense<37> sense<36> sense<35> sense<34> sense<33> sense<32> sense<31> sense<30> sense<29> sense<28> sense<27> sense<26> sense<25> sense<24> sense<23> sense<22> sense<21> sense<20> sense<19> sense<18> sense<17> sense<16> sense<15> sense<14> sense<13> sense<12> sense<11> sense<10> sense<9> sense<8> sense<7> sense<6> sense<5> sense<4> sense<3> sense<2> sense<1> sense<0> sense_b<191> sense_b<190> sense_b<189> sense_b<188> sense_b<187> sense_b<186> sense_b<185> sense_b<184> sense_b<183> sense_b<182> sense_b<181> sense_b<180> sense_b<179> sense_b<178> sense_b<177> sense_b<176> sense_b<175> sense_b<174> sense_b<173> sense_b<172> sense_b<171> sense_b<170> sense_b<169> sense_b<168> sense_b<167> sense_b<166> sense_b<165> sense_b<164> sense_b<163> sense_b<162> sense_b<161>
+sense_b<160> sense_b<159> sense_b<158> sense_b<157> sense_b<156> sense_b<155> sense_b<154> sense_b<153> sense_b<152> sense_b<151> sense_b<150> sense_b<149> sense_b<148> sense_b<147> sense_b<146> sense_b<145> sense_b<144> sense_b<143> sense_b<142> sense_b<141> sense_b<140> sense_b<139> sense_b<138> sense_b<137> sense_b<136> sense_b<135> sense_b<134> sense_b<133> sense_b<132> sense_b<131> sense_b<130> sense_b<129> sense_b<128> sense_b<127> sense_b<126> sense_b<125> sense_b<124> sense_b<123> sense_b<122> sense_b<121> sense_b<120> sense_b<119> sense_b<118> sense_b<117> sense_b<116> sense_b<115> sense_b<114> sense_b<113> sense_b<112> sense_b<111> sense_b<110> sense_b<109> sense_b<108> sense_b<107> sense_b<106> sense_b<105> sense_b<104> sense_b<103> sense_b<102> sense_b<101> sense_b<100> sense_b<99> sense_b<98> sense_b<97> sense_b<96> sense_b<95> sense_b<94> sense_b<93> sense_b<92> sense_b<91> sense_b<90> sense_b<89> sense_b<88> sense_b<87> sense_b<86> sense_b<85> sense_b<84> sense_b<83> sense_b<82> sense_b<81>
+sense_b<80> sense_b<79> sense_b<78> sense_b<77> sense_b<76> sense_b<75> sense_b<74> sense_b<73> sense_b<72> sense_b<71> sense_b<70> sense_b<69> sense_b<68> sense_b<67> sense_b<66> sense_b<65> sense_b<64> sense_b<63> sense_b<62> sense_b<61> sense_b<60> sense_b<59> sense_b<58> sense_b<57> sense_b<56> sense_b<55> sense_b<54> sense_b<53> sense_b<52> sense_b<51> sense_b<50> sense_b<49> sense_b<48> sense_b<47> sense_b<46> sense_b<45> sense_b<44> sense_b<43> sense_b<42> sense_b<41> sense_b<40> sense_b<39> sense_b<38> sense_b<37> sense_b<36> sense_b<35> sense_b<34> sense_b<33> sense_b<32> sense_b<31> sense_b<30> sense_b<29> sense_b<28> sense_b<27> sense_b<26> sense_b<25> sense_b<24> sense_b<23> sense_b<22> sense_b<21> sense_b<20> sense_b<19> sense_b<18> sense_b<17> sense_b<16> sense_b<15> sense_b<14> sense_b<13> sense_b<12> sense_b<11> sense_b<10> sense_b<9> sense_b<8> sense_b<7> sense_b<6> sense_b<5> sense_b<4> sense_b<3> sense_b<2> sense_b<1> sense_b<0>
xi4 b1<63> b1<62> b1<61> b1<60> b1<59> b1<58> b1<57> b1<56> b1<55> b1<54> b1<53> b1<52> b1<51> b1<50> b1<49> b1<48> b1<47> b1<46> b1<45> b1<44> b1<43> b1<42> b1<41> b1<40> b1<39> b1<38> b1<37> b1<36> b1<35> b1<34> b1<33> b1<32> b1<31> b1<30> b1<29> b1<28> b1<27> b1<26> b1<25> b1<24> b1<23> b1<22> b1<21> b1<20> b1<19> b1<18> b1<17> b1<16> b1<15> b1<14> b1<13> b1<12> b1<11> b1<10> b1<9> b1<8> b1<7> b1<6> b1<5> b1<4> b1<3> b1<2> b1<1> b1<0> b<63> b<62> b<61> b<60> b<59> b<58> b<57> b<56> b<55> b<54> b<53> b<52> b<51> b<50> b<49> b<48> b<47> b<46> b<45> b<44> b<43> b<42> b<41> b<40> b<39> b<38> b<37> b<36> b<35> b<34> b<33> b<32> b<31> b<30> b<29> b<28> b<27> b<26> b<25> b<24> b<23> b<22> b<21> b<20> b<19> b<18> b<17> b<16> b<15> b<14> b<13> b<12> b<11> b<10> b<9> b<8> b<7> b<6> b<5> b<4> b<3> b<2> b<1> b<0> en sense<63> sense<62> sense<61> sense<60> sense<59> sense<58> sense<57> sense<56> sense<55> sense<54> sense<53> sense<52> sense<51> sense<50> sense<49> sense<48> sense<47> sense<46> sense<45> sense<44>
+sense<43> sense<42> sense<41> sense<40> sense<39> sense<38> sense<37> sense<36> sense<35> sense<34> sense<33> sense<32> sense<31> sense<30> sense<29> sense<28> sense<27> sense<26> sense<25> sense<24> sense<23> sense<22> sense<21> sense<20> sense<19> sense<18> sense<17> sense<16> sense<15> sense<14> sense<13> sense<12> sense<11> sense<10> sense<9> sense<8> sense<7> sense<6> sense<5> sense<4> sense<3> sense<2> sense<1> sense<0> sense_b<63> sense_b<62> sense_b<61> sense_b<60> sense_b<59> sense_b<58> sense_b<57> sense_b<56> sense_b<55> sense_b<54> sense_b<53> sense_b<52> sense_b<51> sense_b<50> sense_b<49> sense_b<48> sense_b<47> sense_b<46> sense_b<45> sense_b<44> sense_b<43> sense_b<42> sense_b<41> sense_b<40> sense_b<39> sense_b<38> sense_b<37> sense_b<36> sense_b<35> sense_b<34> sense_b<33> sense_b<32> sense_b<31> sense_b<30> sense_b<29> sense_b<28> sense_b<27> sense_b<26> sense_b<25> sense_b<24> sense_b<23> sense_b<22> sense_b<21> sense_b<20> sense_b<19> sense_b<18> sense_b<17> sense_b<16> sense_b<15>
+sense_b<14> sense_b<13> sense_b<12> sense_b<11> sense_b<10> sense_b<9> sense_b<8> sense_b<7> sense_b<6> sense_b<5> sense_b<4> sense_b<3> sense_b<2> sense_b<1> sense_b<0> SAdiff_64
xi2 b1<191> b1<190> b1<189> b1<188> b1<187> b1<186> b1<185> b1<184> b1<183> b1<182> b1<181> b1<180> b1<179> b1<178> b1<177> b1<176> b1<175> b1<174> b1<173> b1<172> b1<171> b1<170> b1<169> b1<168> b1<167> b1<166> b1<165> b1<164> b1<163> b1<162> b1<161> b1<160> b1<159> b1<158> b1<157> b1<156> b1<155> b1<154> b1<153> b1<152> b1<151> b1<150> b1<149> b1<148> b1<147> b1<146> b1<145> b1<144> b1<143> b1<142> b1<141> b1<140> b1<139> b1<138> b1<137> b1<136> b1<135> b1<134> b1<133> b1<132> b1<131> b1<130> b1<129> b1<128> b<191> b<190> b<189> b<188> b<187> b<186> b<185> b<184> b<183> b<182> b<181> b<180> b<179> b<178> b<177> b<176> b<175> b<174> b<173> b<172> b<171> b<170> b<169> b<168> b<167> b<166> b<165> b<164> b<163> b<162> b<161> b<160> b<159> b<158> b<157> b<156> b<155> b<154> b<153> b<152> b<151> b<150> b<149> b<148> b<147> b<146> b<145> b<144> b<143> b<142> b<141> b<140> b<139> b<138> b<137> b<136> b<135> b<134> b<133> b<132> b<131> b<130> b<129> b<128> en sense<191> sense<190> sense<189> sense<188> sense<187>
+sense<186> sense<185> sense<184> sense<183> sense<182> sense<181> sense<180> sense<179> sense<178> sense<177> sense<176> sense<175> sense<174> sense<173> sense<172> sense<171> sense<170> sense<169> sense<168> sense<167> sense<166> sense<165> sense<164> sense<163> sense<162> sense<161> sense<160> sense<159> sense<158> sense<157> sense<156> sense<155> sense<154> sense<153> sense<152> sense<151> sense<150> sense<149> sense<148> sense<147> sense<146> sense<145> sense<144> sense<143> sense<142> sense<141> sense<140> sense<139> sense<138> sense<137> sense<136> sense<135> sense<134> sense<133> sense<132> sense<131> sense<130> sense<129> sense<128> sense_b<191> sense_b<190> sense_b<189> sense_b<188> sense_b<187> sense_b<186> sense_b<185> sense_b<184> sense_b<183> sense_b<182> sense_b<181> sense_b<180> sense_b<179> sense_b<178> sense_b<177> sense_b<176> sense_b<175> sense_b<174> sense_b<173> sense_b<172> sense_b<171> sense_b<170> sense_b<169> sense_b<168> sense_b<167> sense_b<166> sense_b<165> sense_b<164>
+sense_b<163> sense_b<162> sense_b<161> sense_b<160> sense_b<159> sense_b<158> sense_b<157> sense_b<156> sense_b<155> sense_b<154> sense_b<153> sense_b<152> sense_b<151> sense_b<150> sense_b<149> sense_b<148> sense_b<147> sense_b<146> sense_b<145> sense_b<144> sense_b<143> sense_b<142> sense_b<141> sense_b<140> sense_b<139> sense_b<138> sense_b<137> sense_b<136> sense_b<135> sense_b<134> sense_b<133> sense_b<132> sense_b<131> sense_b<130> sense_b<129> sense_b<128> SAdiff_64
xi3 b1<127> b1<126> b1<125> b1<124> b1<123> b1<122> b1<121> b1<120> b1<119> b1<118> b1<117> b1<116> b1<115> b1<114> b1<113> b1<112> b1<111> b1<110> b1<109> b1<108> b1<107> b1<106> b1<105> b1<104> b1<103> b1<102> b1<101> b1<100> b1<99> b1<98> b1<97> b1<96> b1<95> b1<94> b1<93> b1<92> b1<91> b1<90> b1<89> b1<88> b1<87> b1<86> b1<85> b1<84> b1<83> b1<82> b1<81> b1<80> b1<79> b1<78> b1<77> b1<76> b1<75> b1<74> b1<73> b1<72> b1<71> b1<70> b1<69> b1<68> b1<67> b1<66> b1<65> b1<64> b<127> b<126> b<125> b<124> b<123> b<122> b<121> b<120> b<119> b<118> b<117> b<116> b<115> b<114> b<113> b<112> b<111> b<110> b<109> b<108> b<107> b<106> b<105> b<104> b<103> b<102> b<101> b<100> b<99> b<98> b<97> b<96> b<95> b<94> b<93> b<92> b<91> b<90> b<89> b<88> b<87> b<86> b<85> b<84> b<83> b<82> b<81> b<80> b<79> b<78> b<77> b<76> b<75> b<74> b<73> b<72> b<71> b<70> b<69> b<68> b<67> b<66> b<65> b<64> en sense<127> sense<126> sense<125> sense<124> sense<123> sense<122> sense<121> sense<120> sense<119> sense<118> sense<117>
+sense<116> sense<115> sense<114> sense<113> sense<112> sense<111> sense<110> sense<109> sense<108> sense<107> sense<106> sense<105> sense<104> sense<103> sense<102> sense<101> sense<100> sense<99> sense<98> sense<97> sense<96> sense<95> sense<94> sense<93> sense<92> sense<91> sense<90> sense<89> sense<88> sense<87> sense<86> sense<85> sense<84> sense<83> sense<82> sense<81> sense<80> sense<79> sense<78> sense<77> sense<76> sense<75> sense<74> sense<73> sense<72> sense<71> sense<70> sense<69> sense<68> sense<67> sense<66> sense<65> sense<64> sense_b<127> sense_b<126> sense_b<125> sense_b<124> sense_b<123> sense_b<122> sense_b<121> sense_b<120> sense_b<119> sense_b<118> sense_b<117> sense_b<116> sense_b<115> sense_b<114> sense_b<113> sense_b<112> sense_b<111> sense_b<110> sense_b<109> sense_b<108> sense_b<107> sense_b<106> sense_b<105> sense_b<104> sense_b<103> sense_b<102> sense_b<101> sense_b<100> sense_b<99> sense_b<98> sense_b<97> sense_b<96> sense_b<95> sense_b<94> sense_b<93> sense_b<92> sense_b<91>
+sense_b<90> sense_b<89> sense_b<88> sense_b<87> sense_b<86> sense_b<85> sense_b<84> sense_b<83> sense_b<82> sense_b<81> sense_b<80> sense_b<79> sense_b<78> sense_b<77> sense_b<76> sense_b<75> sense_b<74> sense_b<73> sense_b<72> sense_b<71> sense_b<70> sense_b<69> sense_b<68> sense_b<67> sense_b<66> sense_b<65> sense_b<64> SAdiff_64
.ends SAdiff_192
** End of subcircuit definition.

** Library name: EE213CAN45nm
** Cell name: SRAM_TOTAL
** View name: schematic
.subckt SRAM_TOTAL prc read_data<191> read_data<190> read_data<189> read_data<188> read_data<187> read_data<186> read_data<185> read_data<184> read_data<183> read_data<182> read_data<181> read_data<180> read_data<179> read_data<178> read_data<177> read_data<176> read_data<175> read_data<174> read_data<173> read_data<172> read_data<171> read_data<170> read_data<169> read_data<168> read_data<167> read_data<166> read_data<165> read_data<164> read_data<163> read_data<162> read_data<161> read_data<160> read_data<159> read_data<158> read_data<157> read_data<156> read_data<155> read_data<154> read_data<153> read_data<152> read_data<151> read_data<150> read_data<149> read_data<148> read_data<147> read_data<146> read_data<145> read_data<144> read_data<143> read_data<142> read_data<141> read_data<140> read_data<139> read_data<138> read_data<137> read_data<136> read_data<135> read_data<134> read_data<133> read_data<132> read_data<131> read_data<130> read_data<129> read_data<128> read_data<127> read_data<126>
+read_data<125> read_data<124> read_data<123> read_data<122> read_data<121> read_data<120> read_data<119> read_data<118> read_data<117> read_data<116> read_data<115> read_data<114> read_data<113> read_data<112> read_data<111> read_data<110> read_data<109> read_data<108> read_data<107> read_data<106> read_data<105> read_data<104> read_data<103> read_data<102> read_data<101> read_data<100> read_data<99> read_data<98> read_data<97> read_data<96> read_data<95> read_data<94> read_data<93> read_data<92> read_data<91> read_data<90> read_data<89> read_data<88> read_data<87> read_data<86> read_data<85> read_data<84> read_data<83> read_data<82> read_data<81> read_data<80> read_data<79> read_data<78> read_data<77> read_data<76> read_data<75> read_data<74> read_data<73> read_data<72> read_data<71> read_data<70> read_data<69> read_data<68> read_data<67> read_data<66> read_data<65> read_data<64> read_data<63> read_data<62> read_data<61> read_data<60> read_data<59> read_data<58> read_data<57> read_data<56> read_data<55>
+read_data<54> read_data<53> read_data<52> read_data<51> read_data<50> read_data<49> read_data<48> read_data<47> read_data<46> read_data<45> read_data<44> read_data<43> read_data<42> read_data<41> read_data<40> read_data<39> read_data<38> read_data<37> read_data<36> read_data<35> read_data<34> read_data<33> read_data<32> read_data<31> read_data<30> read_data<29> read_data<28> read_data<27> read_data<26> read_data<25> read_data<24> read_data<23> read_data<22> read_data<21> read_data<20> read_data<19> read_data<18> read_data<17> read_data<16> read_data<15> read_data<14> read_data<13> read_data<12> read_data<11> read_data<10> read_data<9> read_data<8> read_data<7> read_data<6> read_data<5> read_data<4> read_data<3> read_data<2> read_data<1> read_data<0> wl<0> wl<10> wl<11> wl<12> wl<13> wl<14> wl<15> wl<16> wl<17> wl<18> wl<19> wl<1> wl<20> wl<21> wl<22> wl<23> wl<24> wl<25> wl<26> wl<27> wl<28> wl<29> wl<2> wl<30> wl<31> wl<3> wl<4> wl<5> wl<6> wl<7> wl<8> wl<9> write_data<191> write_data<190> write_data<189>
+write_data<188> write_data<187> write_data<186> write_data<185> write_data<184> write_data<183> write_data<182> write_data<181> write_data<180> write_data<179> write_data<178> write_data<177> write_data<176> write_data<175> write_data<174> write_data<173> write_data<172> write_data<171> write_data<170> write_data<169> write_data<168> write_data<167> write_data<166> write_data<165> write_data<164> write_data<163> write_data<162> write_data<161> write_data<160> write_data<159> write_data<158> write_data<157> write_data<156> write_data<155> write_data<154> write_data<153> write_data<152> write_data<151> write_data<150> write_data<149> write_data<148> write_data<147> write_data<146> write_data<145> write_data<144> write_data<143> write_data<142> write_data<141> write_data<140> write_data<139> write_data<138> write_data<137> write_data<136> write_data<135> write_data<134> write_data<133> write_data<132> write_data<131> write_data<130> write_data<129> write_data<128> write_data<127> write_data<126>
+write_data<125> write_data<124> write_data<123> write_data<122> write_data<121> write_data<120> write_data<119> write_data<118> write_data<117> write_data<116> write_data<115> write_data<114> write_data<113> write_data<112> write_data<111> write_data<110> write_data<109> write_data<108> write_data<107> write_data<106> write_data<105> write_data<104> write_data<103> write_data<102> write_data<101> write_data<100> write_data<99> write_data<98> write_data<97> write_data<96> write_data<95> write_data<94> write_data<93> write_data<92> write_data<91> write_data<90> write_data<89> write_data<88> write_data<87> write_data<86> write_data<85> write_data<84> write_data<83> write_data<82> write_data<81> write_data<80> write_data<79> write_data<78> write_data<77> write_data<76> write_data<75> write_data<74> write_data<73> write_data<72> write_data<71> write_data<70> write_data<69> write_data<68> write_data<67> write_data<66> write_data<65> write_data<64> write_data<63> write_data<62> write_data<61> write_data<60>
+write_data<59> write_data<58> write_data<57> write_data<56> write_data<55> write_data<54> write_data<53> write_data<52> write_data<51> write_data<50> write_data<49> write_data<48> write_data<47> write_data<46> write_data<45> write_data<44> write_data<43> write_data<42> write_data<41> write_data<40> write_data<39> write_data<38> write_data<37> write_data<36> write_data<35> write_data<34> write_data<33> write_data<32> write_data<31> write_data<30> write_data<29> write_data<28> write_data<27> write_data<26> write_data<25> write_data<24> write_data<23> write_data<22> write_data<21> write_data<20> write_data<19> write_data<18> write_data<17> write_data<16> write_data<15> write_data<14> write_data<13> write_data<12> write_data<11> write_data<10> write_data<9> write_data<8> write_data<7> write_data<6> write_data<5> write_data<4> write_data<3> write_data<2> write_data<1> write_data<0> read_en sense_b<191> sense_b<190> sense_b<189> sense_b<188> sense_b<187> sense_b<186> sense_b<185> sense_b<184> sense_b<183>
+sense_b<182> sense_b<181> sense_b<180> sense_b<179> sense_b<178> sense_b<177> sense_b<176> sense_b<175> sense_b<174> sense_b<173> sense_b<172> sense_b<171> sense_b<170> sense_b<169> sense_b<168> sense_b<167> sense_b<166> sense_b<165> sense_b<164> sense_b<163> sense_b<162> sense_b<161> sense_b<160> sense_b<159> sense_b<158> sense_b<157> sense_b<156> sense_b<155> sense_b<154> sense_b<153> sense_b<152> sense_b<151> sense_b<150> sense_b<149> sense_b<148> sense_b<147> sense_b<146> sense_b<145> sense_b<144> sense_b<143> sense_b<142> sense_b<141> sense_b<140> sense_b<139> sense_b<138> sense_b<137> sense_b<136> sense_b<135> sense_b<134> sense_b<133> sense_b<132> sense_b<131> sense_b<130> sense_b<129> sense_b<128> sense_b<127> sense_b<126> sense_b<125> sense_b<124> sense_b<123> sense_b<122> sense_b<121> sense_b<120> sense_b<119> sense_b<118> sense_b<117> sense_b<116> sense_b<115> sense_b<114> sense_b<113> sense_b<112> sense_b<111> sense_b<110> sense_b<109> sense_b<108> sense_b<107> sense_b<106> sense_b<105>
+sense_b<104> sense_b<103> sense_b<102> sense_b<101> sense_b<100> sense_b<99> sense_b<98> sense_b<97> sense_b<96> sense_b<95> sense_b<94> sense_b<93> sense_b<92> sense_b<91> sense_b<90> sense_b<89> sense_b<88> sense_b<87> sense_b<86> sense_b<85> sense_b<84> sense_b<83> sense_b<82> sense_b<81> sense_b<80> sense_b<79> sense_b<78> sense_b<77> sense_b<76> sense_b<75> sense_b<74> sense_b<73> sense_b<72> sense_b<71> sense_b<70> sense_b<69> sense_b<68> sense_b<67> sense_b<66> sense_b<65> sense_b<64> sense_b<63> sense_b<62> sense_b<61> sense_b<60> sense_b<59> sense_b<58> sense_b<57> sense_b<56> sense_b<55> sense_b<54> sense_b<53> sense_b<52> sense_b<51> sense_b<50> sense_b<49> sense_b<48> sense_b<47> sense_b<46> sense_b<45> sense_b<44> sense_b<43> sense_b<42> sense_b<41> sense_b<40> sense_b<39> sense_b<38> sense_b<37> sense_b<36> sense_b<35> sense_b<34> sense_b<33> sense_b<32> sense_b<31> sense_b<30> sense_b<29> sense_b<28> sense_b<27> sense_b<26> sense_b<25> sense_b<24> sense_b<23> sense_b<22> sense_b<21>
+sense_b<20> sense_b<19> sense_b<18> sense_b<17> sense_b<16> sense_b<15> sense_b<14> sense_b<13> sense_b<12> sense_b<11> sense_b<10> sense_b<9> sense_b<8> sense_b<7> sense_b<6> sense_b<5> sense_b<4> sense_b<3> sense_b<2> sense_b<1> sense_b<0> write_en
xi0 prc b1<191> b1<190> b1<189> b1<188> b1<187> b1<186> b1<185> b1<184> b1<183> b1<182> b1<181> b1<180> b1<179> b1<178> b1<177> b1<176> b1<175> b1<174> b1<173> b1<172> b1<171> b1<170> b1<169> b1<168> b1<167> b1<166> b1<165> b1<164> b1<163> b1<162> b1<161> b1<160> b1<159> b1<158> b1<157> b1<156> b1<155> b1<154> b1<153> b1<152> b1<151> b1<150> b1<149> b1<148> b1<147> b1<146> b1<145> b1<144> b1<143> b1<142> b1<141> b1<140> b1<139> b1<138> b1<137> b1<136> b1<135> b1<134> b1<133> b1<132> b1<131> b1<130> b1<129> b1<128> b1<127> b1<126> b1<125> b1<124> b1<123> b1<122> b1<121> b1<120> b1<119> b1<118> b1<117> b1<116> b1<115> b1<114> b1<113> b1<112> b1<111> b1<110> b1<109> b1<108> b1<107> b1<106> b1<105> b1<104> b1<103> b1<102> b1<101> b1<100> b1<99> b1<98> b1<97> b1<96> b1<95> b1<94> b1<93> b1<92> b1<91> b1<90> b1<89> b1<88> b1<87> b1<86> b1<85> b1<84> b1<83> b1<82> b1<81> b1<80> b1<79> b1<78> b1<77> b1<76> b1<75> b1<74> b1<73> b1<72> b1<71> b1<70> b1<69> b1<68> b1<67> b1<66> b1<65> b1<64> b1<63> b1<62> b1<61> b1<60>
+b1<59> b1<58> b1<57> b1<56> b1<55> b1<54> b1<53> b1<52> b1<51> b1<50> b1<49> b1<48> b1<47> b1<46> b1<45> b1<44> b1<43> b1<42> b1<41> b1<40> b1<39> b1<38> b1<37> b1<36> b1<35> b1<34> b1<33> b1<32> b1<31> b1<30> b1<29> b1<28> b1<27> b1<26> b1<25> b1<24> b1<23> b1<22> b1<21> b1<20> b1<19> b1<18> b1<17> b1<16> b1<15> b1<14> b1<13> b1<12> b1<11> b1<10> b1<9> b1<8> b1<7> b1<6> b1<5> b1<4> b1<3> b1<2> b1<1> b1<0> b<191> b<190> b<189> b<188> b<187> b<186> b<185> b<184> b<183> b<182> b<181> b<180> b<179> b<178> b<177> b<176> b<175> b<174> b<173> b<172> b<171> b<170> b<169> b<168> b<167> b<166> b<165> b<164> b<163> b<162> b<161> b<160> b<159> b<158> b<157> b<156> b<155> b<154> b<153> b<152> b<151> b<150> b<149> b<148> b<147> b<146> b<145> b<144> b<143> b<142> b<141> b<140> b<139> b<138> b<137> b<136> b<135> b<134> b<133> b<132> b<131> b<130> b<129> b<128> b<127> b<126> b<125> b<124> b<123> b<122> b<121> b<120> b<119> b<118> b<117> b<116> b<115> b<114> b<113> b<112> b<111> b<110> b<109> b<108> b<107> b<106> b<105>
+b<104> b<103> b<102> b<101> b<100> b<99> b<98> b<97> b<96> b<95> b<94> b<93> b<92> b<91> b<90> b<89> b<88> b<87> b<86> b<85> b<84> b<83> b<82> b<81> b<80> b<79> b<78> b<77> b<76> b<75> b<74> b<73> b<72> b<71> b<70> b<69> b<68> b<67> b<66> b<65> b<64> b<63> b<62> b<61> b<60> b<59> b<58> b<57> b<56> b<55> b<54> b<53> b<52> b<51> b<50> b<49> b<48> b<47> b<46> b<45> b<44> b<43> b<42> b<41> b<40> b<39> b<38> b<37> b<36> b<35> b<34> b<33> b<32> b<31> b<30> b<29> b<28> b<27> b<26> b<25> b<24> b<23> b<22> b<21> b<20> b<19> b<18> b<17> b<16> b<15> b<14> b<13> b<12> b<11> b<10> b<9> b<8> b<7> b<6> b<5> b<4> b<3> b<2> b<1> b<0> pre_192
xi35 wl<0> b1<191> b1<190> b1<189> b1<188> b1<187> b1<186> b1<185> b1<184> b1<183> b1<182> b1<181> b1<180> b1<179> b1<178> b1<177> b1<176> b1<175> b1<174> b1<173> b1<172> b1<171> b1<170> b1<169> b1<168> b1<167> b1<166> b1<165> b1<164> b1<163> b1<162> b1<161> b1<160> b1<159> b1<158> b1<157> b1<156> b1<155> b1<154> b1<153> b1<152> b1<151> b1<150> b1<149> b1<148> b1<147> b1<146> b1<145> b1<144> b1<143> b1<142> b1<141> b1<140> b1<139> b1<138> b1<137> b1<136> b1<135> b1<134> b1<133> b1<132> b1<131> b1<130> b1<129> b1<128> b1<127> b1<126> b1<125> b1<124> b1<123> b1<122> b1<121> b1<120> b1<119> b1<118> b1<117> b1<116> b1<115> b1<114> b1<113> b1<112> b1<111> b1<110> b1<109> b1<108> b1<107> b1<106> b1<105> b1<104> b1<103> b1<102> b1<101> b1<100> b1<99> b1<98> b1<97> b1<96> b1<95> b1<94> b1<93> b1<92> b1<91> b1<90> b1<89> b1<88> b1<87> b1<86> b1<85> b1<84> b1<83> b1<82> b1<81> b1<80> b1<79> b1<78> b1<77> b1<76> b1<75> b1<74> b1<73> b1<72> b1<71> b1<70> b1<69> b1<68> b1<67> b1<66> b1<65> b1<64> b1<63> b1<62> b1<61>
+b1<60> b1<59> b1<58> b1<57> b1<56> b1<55> b1<54> b1<53> b1<52> b1<51> b1<50> b1<49> b1<48> b1<47> b1<46> b1<45> b1<44> b1<43> b1<42> b1<41> b1<40> b1<39> b1<38> b1<37> b1<36> b1<35> b1<34> b1<33> b1<32> b1<31> b1<30> b1<29> b1<28> b1<27> b1<26> b1<25> b1<24> b1<23> b1<22> b1<21> b1<20> b1<19> b1<18> b1<17> b1<16> b1<15> b1<14> b1<13> b1<12> b1<11> b1<10> b1<9> b1<8> b1<7> b1<6> b1<5> b1<4> b1<3> b1<2> b1<1> b1<0> b<191> b<190> b<189> b<188> b<187> b<186> b<185> b<184> b<183> b<182> b<181> b<180> b<179> b<178> b<177> b<176> b<175> b<174> b<173> b<172> b<171> b<170> b<169> b<168> b<167> b<166> b<165> b<164> b<163> b<162> b<161> b<160> b<159> b<158> b<157> b<156> b<155> b<154> b<153> b<152> b<151> b<150> b<149> b<148> b<147> b<146> b<145> b<144> b<143> b<142> b<141> b<140> b<139> b<138> b<137> b<136> b<135> b<134> b<133> b<132> b<131> b<130> b<129> b<128> b<127> b<126> b<125> b<124> b<123> b<122> b<121> b<120> b<119> b<118> b<117> b<116> b<115> b<114> b<113> b<112> b<111> b<110> b<109> b<108> b<107> b<106>
+b<105> b<104> b<103> b<102> b<101> b<100> b<99> b<98> b<97> b<96> b<95> b<94> b<93> b<92> b<91> b<90> b<89> b<88> b<87> b<86> b<85> b<84> b<83> b<82> b<81> b<80> b<79> b<78> b<77> b<76> b<75> b<74> b<73> b<72> b<71> b<70> b<69> b<68> b<67> b<66> b<65> b<64> b<63> b<62> b<61> b<60> b<59> b<58> b<57> b<56> b<55> b<54> b<53> b<52> b<51> b<50> b<49> b<48> b<47> b<46> b<45> b<44> b<43> b<42> b<41> b<40> b<39> b<38> b<37> b<36> b<35> b<34> b<33> b<32> b<31> b<30> b<29> b<28> b<27> b<26> b<25> b<24> b<23> b<22> b<21> b<20> b<19> b<18> b<17> b<16> b<15> b<14> b<13> b<12> b<11> b<10> b<9> b<8> b<7> b<6> b<5> b<4> b<3> b<2> b<1> b<0> SRAM_192
xi34 wl<1> b1<191> b1<190> b1<189> b1<188> b1<187> b1<186> b1<185> b1<184> b1<183> b1<182> b1<181> b1<180> b1<179> b1<178> b1<177> b1<176> b1<175> b1<174> b1<173> b1<172> b1<171> b1<170> b1<169> b1<168> b1<167> b1<166> b1<165> b1<164> b1<163> b1<162> b1<161> b1<160> b1<159> b1<158> b1<157> b1<156> b1<155> b1<154> b1<153> b1<152> b1<151> b1<150> b1<149> b1<148> b1<147> b1<146> b1<145> b1<144> b1<143> b1<142> b1<141> b1<140> b1<139> b1<138> b1<137> b1<136> b1<135> b1<134> b1<133> b1<132> b1<131> b1<130> b1<129> b1<128> b1<127> b1<126> b1<125> b1<124> b1<123> b1<122> b1<121> b1<120> b1<119> b1<118> b1<117> b1<116> b1<115> b1<114> b1<113> b1<112> b1<111> b1<110> b1<109> b1<108> b1<107> b1<106> b1<105> b1<104> b1<103> b1<102> b1<101> b1<100> b1<99> b1<98> b1<97> b1<96> b1<95> b1<94> b1<93> b1<92> b1<91> b1<90> b1<89> b1<88> b1<87> b1<86> b1<85> b1<84> b1<83> b1<82> b1<81> b1<80> b1<79> b1<78> b1<77> b1<76> b1<75> b1<74> b1<73> b1<72> b1<71> b1<70> b1<69> b1<68> b1<67> b1<66> b1<65> b1<64> b1<63> b1<62> b1<61>
+b1<60> b1<59> b1<58> b1<57> b1<56> b1<55> b1<54> b1<53> b1<52> b1<51> b1<50> b1<49> b1<48> b1<47> b1<46> b1<45> b1<44> b1<43> b1<42> b1<41> b1<40> b1<39> b1<38> b1<37> b1<36> b1<35> b1<34> b1<33> b1<32> b1<31> b1<30> b1<29> b1<28> b1<27> b1<26> b1<25> b1<24> b1<23> b1<22> b1<21> b1<20> b1<19> b1<18> b1<17> b1<16> b1<15> b1<14> b1<13> b1<12> b1<11> b1<10> b1<9> b1<8> b1<7> b1<6> b1<5> b1<4> b1<3> b1<2> b1<1> b1<0> b<191> b<190> b<189> b<188> b<187> b<186> b<185> b<184> b<183> b<182> b<181> b<180> b<179> b<178> b<177> b<176> b<175> b<174> b<173> b<172> b<171> b<170> b<169> b<168> b<167> b<166> b<165> b<164> b<163> b<162> b<161> b<160> b<159> b<158> b<157> b<156> b<155> b<154> b<153> b<152> b<151> b<150> b<149> b<148> b<147> b<146> b<145> b<144> b<143> b<142> b<141> b<140> b<139> b<138> b<137> b<136> b<135> b<134> b<133> b<132> b<131> b<130> b<129> b<128> b<127> b<126> b<125> b<124> b<123> b<122> b<121> b<120> b<119> b<118> b<117> b<116> b<115> b<114> b<113> b<112> b<111> b<110> b<109> b<108> b<107> b<106>
+b<105> b<104> b<103> b<102> b<101> b<100> b<99> b<98> b<97> b<96> b<95> b<94> b<93> b<92> b<91> b<90> b<89> b<88> b<87> b<86> b<85> b<84> b<83> b<82> b<81> b<80> b<79> b<78> b<77> b<76> b<75> b<74> b<73> b<72> b<71> b<70> b<69> b<68> b<67> b<66> b<65> b<64> b<63> b<62> b<61> b<60> b<59> b<58> b<57> b<56> b<55> b<54> b<53> b<52> b<51> b<50> b<49> b<48> b<47> b<46> b<45> b<44> b<43> b<42> b<41> b<40> b<39> b<38> b<37> b<36> b<35> b<34> b<33> b<32> b<31> b<30> b<29> b<28> b<27> b<26> b<25> b<24> b<23> b<22> b<21> b<20> b<19> b<18> b<17> b<16> b<15> b<14> b<13> b<12> b<11> b<10> b<9> b<8> b<7> b<6> b<5> b<4> b<3> b<2> b<1> b<0> SRAM_192
xi33 wl<2> b1<191> b1<190> b1<189> b1<188> b1<187> b1<186> b1<185> b1<184> b1<183> b1<182> b1<181> b1<180> b1<179> b1<178> b1<177> b1<176> b1<175> b1<174> b1<173> b1<172> b1<171> b1<170> b1<169> b1<168> b1<167> b1<166> b1<165> b1<164> b1<163> b1<162> b1<161> b1<160> b1<159> b1<158> b1<157> b1<156> b1<155> b1<154> b1<153> b1<152> b1<151> b1<150> b1<149> b1<148> b1<147> b1<146> b1<145> b1<144> b1<143> b1<142> b1<141> b1<140> b1<139> b1<138> b1<137> b1<136> b1<135> b1<134> b1<133> b1<132> b1<131> b1<130> b1<129> b1<128> b1<127> b1<126> b1<125> b1<124> b1<123> b1<122> b1<121> b1<120> b1<119> b1<118> b1<117> b1<116> b1<115> b1<114> b1<113> b1<112> b1<111> b1<110> b1<109> b1<108> b1<107> b1<106> b1<105> b1<104> b1<103> b1<102> b1<101> b1<100> b1<99> b1<98> b1<97> b1<96> b1<95> b1<94> b1<93> b1<92> b1<91> b1<90> b1<89> b1<88> b1<87> b1<86> b1<85> b1<84> b1<83> b1<82> b1<81> b1<80> b1<79> b1<78> b1<77> b1<76> b1<75> b1<74> b1<73> b1<72> b1<71> b1<70> b1<69> b1<68> b1<67> b1<66> b1<65> b1<64> b1<63> b1<62> b1<61>
+b1<60> b1<59> b1<58> b1<57> b1<56> b1<55> b1<54> b1<53> b1<52> b1<51> b1<50> b1<49> b1<48> b1<47> b1<46> b1<45> b1<44> b1<43> b1<42> b1<41> b1<40> b1<39> b1<38> b1<37> b1<36> b1<35> b1<34> b1<33> b1<32> b1<31> b1<30> b1<29> b1<28> b1<27> b1<26> b1<25> b1<24> b1<23> b1<22> b1<21> b1<20> b1<19> b1<18> b1<17> b1<16> b1<15> b1<14> b1<13> b1<12> b1<11> b1<10> b1<9> b1<8> b1<7> b1<6> b1<5> b1<4> b1<3> b1<2> b1<1> b1<0> b<191> b<190> b<189> b<188> b<187> b<186> b<185> b<184> b<183> b<182> b<181> b<180> b<179> b<178> b<177> b<176> b<175> b<174> b<173> b<172> b<171> b<170> b<169> b<168> b<167> b<166> b<165> b<164> b<163> b<162> b<161> b<160> b<159> b<158> b<157> b<156> b<155> b<154> b<153> b<152> b<151> b<150> b<149> b<148> b<147> b<146> b<145> b<144> b<143> b<142> b<141> b<140> b<139> b<138> b<137> b<136> b<135> b<134> b<133> b<132> b<131> b<130> b<129> b<128> b<127> b<126> b<125> b<124> b<123> b<122> b<121> b<120> b<119> b<118> b<117> b<116> b<115> b<114> b<113> b<112> b<111> b<110> b<109> b<108> b<107> b<106>
+b<105> b<104> b<103> b<102> b<101> b<100> b<99> b<98> b<97> b<96> b<95> b<94> b<93> b<92> b<91> b<90> b<89> b<88> b<87> b<86> b<85> b<84> b<83> b<82> b<81> b<80> b<79> b<78> b<77> b<76> b<75> b<74> b<73> b<72> b<71> b<70> b<69> b<68> b<67> b<66> b<65> b<64> b<63> b<62> b<61> b<60> b<59> b<58> b<57> b<56> b<55> b<54> b<53> b<52> b<51> b<50> b<49> b<48> b<47> b<46> b<45> b<44> b<43> b<42> b<41> b<40> b<39> b<38> b<37> b<36> b<35> b<34> b<33> b<32> b<31> b<30> b<29> b<28> b<27> b<26> b<25> b<24> b<23> b<22> b<21> b<20> b<19> b<18> b<17> b<16> b<15> b<14> b<13> b<12> b<11> b<10> b<9> b<8> b<7> b<6> b<5> b<4> b<3> b<2> b<1> b<0> SRAM_192
xi32 wl<3> b1<191> b1<190> b1<189> b1<188> b1<187> b1<186> b1<185> b1<184> b1<183> b1<182> b1<181> b1<180> b1<179> b1<178> b1<177> b1<176> b1<175> b1<174> b1<173> b1<172> b1<171> b1<170> b1<169> b1<168> b1<167> b1<166> b1<165> b1<164> b1<163> b1<162> b1<161> b1<160> b1<159> b1<158> b1<157> b1<156> b1<155> b1<154> b1<153> b1<152> b1<151> b1<150> b1<149> b1<148> b1<147> b1<146> b1<145> b1<144> b1<143> b1<142> b1<141> b1<140> b1<139> b1<138> b1<137> b1<136> b1<135> b1<134> b1<133> b1<132> b1<131> b1<130> b1<129> b1<128> b1<127> b1<126> b1<125> b1<124> b1<123> b1<122> b1<121> b1<120> b1<119> b1<118> b1<117> b1<116> b1<115> b1<114> b1<113> b1<112> b1<111> b1<110> b1<109> b1<108> b1<107> b1<106> b1<105> b1<104> b1<103> b1<102> b1<101> b1<100> b1<99> b1<98> b1<97> b1<96> b1<95> b1<94> b1<93> b1<92> b1<91> b1<90> b1<89> b1<88> b1<87> b1<86> b1<85> b1<84> b1<83> b1<82> b1<81> b1<80> b1<79> b1<78> b1<77> b1<76> b1<75> b1<74> b1<73> b1<72> b1<71> b1<70> b1<69> b1<68> b1<67> b1<66> b1<65> b1<64> b1<63> b1<62> b1<61>
+b1<60> b1<59> b1<58> b1<57> b1<56> b1<55> b1<54> b1<53> b1<52> b1<51> b1<50> b1<49> b1<48> b1<47> b1<46> b1<45> b1<44> b1<43> b1<42> b1<41> b1<40> b1<39> b1<38> b1<37> b1<36> b1<35> b1<34> b1<33> b1<32> b1<31> b1<30> b1<29> b1<28> b1<27> b1<26> b1<25> b1<24> b1<23> b1<22> b1<21> b1<20> b1<19> b1<18> b1<17> b1<16> b1<15> b1<14> b1<13> b1<12> b1<11> b1<10> b1<9> b1<8> b1<7> b1<6> b1<5> b1<4> b1<3> b1<2> b1<1> b1<0> b<191> b<190> b<189> b<188> b<187> b<186> b<185> b<184> b<183> b<182> b<181> b<180> b<179> b<178> b<177> b<176> b<175> b<174> b<173> b<172> b<171> b<170> b<169> b<168> b<167> b<166> b<165> b<164> b<163> b<162> b<161> b<160> b<159> b<158> b<157> b<156> b<155> b<154> b<153> b<152> b<151> b<150> b<149> b<148> b<147> b<146> b<145> b<144> b<143> b<142> b<141> b<140> b<139> b<138> b<137> b<136> b<135> b<134> b<133> b<132> b<131> b<130> b<129> b<128> b<127> b<126> b<125> b<124> b<123> b<122> b<121> b<120> b<119> b<118> b<117> b<116> b<115> b<114> b<113> b<112> b<111> b<110> b<109> b<108> b<107> b<106>
+b<105> b<104> b<103> b<102> b<101> b<100> b<99> b<98> b<97> b<96> b<95> b<94> b<93> b<92> b<91> b<90> b<89> b<88> b<87> b<86> b<85> b<84> b<83> b<82> b<81> b<80> b<79> b<78> b<77> b<76> b<75> b<74> b<73> b<72> b<71> b<70> b<69> b<68> b<67> b<66> b<65> b<64> b<63> b<62> b<61> b<60> b<59> b<58> b<57> b<56> b<55> b<54> b<53> b<52> b<51> b<50> b<49> b<48> b<47> b<46> b<45> b<44> b<43> b<42> b<41> b<40> b<39> b<38> b<37> b<36> b<35> b<34> b<33> b<32> b<31> b<30> b<29> b<28> b<27> b<26> b<25> b<24> b<23> b<22> b<21> b<20> b<19> b<18> b<17> b<16> b<15> b<14> b<13> b<12> b<11> b<10> b<9> b<8> b<7> b<6> b<5> b<4> b<3> b<2> b<1> b<0> SRAM_192
xi31 wl<4> b1<191> b1<190> b1<189> b1<188> b1<187> b1<186> b1<185> b1<184> b1<183> b1<182> b1<181> b1<180> b1<179> b1<178> b1<177> b1<176> b1<175> b1<174> b1<173> b1<172> b1<171> b1<170> b1<169> b1<168> b1<167> b1<166> b1<165> b1<164> b1<163> b1<162> b1<161> b1<160> b1<159> b1<158> b1<157> b1<156> b1<155> b1<154> b1<153> b1<152> b1<151> b1<150> b1<149> b1<148> b1<147> b1<146> b1<145> b1<144> b1<143> b1<142> b1<141> b1<140> b1<139> b1<138> b1<137> b1<136> b1<135> b1<134> b1<133> b1<132> b1<131> b1<130> b1<129> b1<128> b1<127> b1<126> b1<125> b1<124> b1<123> b1<122> b1<121> b1<120> b1<119> b1<118> b1<117> b1<116> b1<115> b1<114> b1<113> b1<112> b1<111> b1<110> b1<109> b1<108> b1<107> b1<106> b1<105> b1<104> b1<103> b1<102> b1<101> b1<100> b1<99> b1<98> b1<97> b1<96> b1<95> b1<94> b1<93> b1<92> b1<91> b1<90> b1<89> b1<88> b1<87> b1<86> b1<85> b1<84> b1<83> b1<82> b1<81> b1<80> b1<79> b1<78> b1<77> b1<76> b1<75> b1<74> b1<73> b1<72> b1<71> b1<70> b1<69> b1<68> b1<67> b1<66> b1<65> b1<64> b1<63> b1<62> b1<61>
+b1<60> b1<59> b1<58> b1<57> b1<56> b1<55> b1<54> b1<53> b1<52> b1<51> b1<50> b1<49> b1<48> b1<47> b1<46> b1<45> b1<44> b1<43> b1<42> b1<41> b1<40> b1<39> b1<38> b1<37> b1<36> b1<35> b1<34> b1<33> b1<32> b1<31> b1<30> b1<29> b1<28> b1<27> b1<26> b1<25> b1<24> b1<23> b1<22> b1<21> b1<20> b1<19> b1<18> b1<17> b1<16> b1<15> b1<14> b1<13> b1<12> b1<11> b1<10> b1<9> b1<8> b1<7> b1<6> b1<5> b1<4> b1<3> b1<2> b1<1> b1<0> b<191> b<190> b<189> b<188> b<187> b<186> b<185> b<184> b<183> b<182> b<181> b<180> b<179> b<178> b<177> b<176> b<175> b<174> b<173> b<172> b<171> b<170> b<169> b<168> b<167> b<166> b<165> b<164> b<163> b<162> b<161> b<160> b<159> b<158> b<157> b<156> b<155> b<154> b<153> b<152> b<151> b<150> b<149> b<148> b<147> b<146> b<145> b<144> b<143> b<142> b<141> b<140> b<139> b<138> b<137> b<136> b<135> b<134> b<133> b<132> b<131> b<130> b<129> b<128> b<127> b<126> b<125> b<124> b<123> b<122> b<121> b<120> b<119> b<118> b<117> b<116> b<115> b<114> b<113> b<112> b<111> b<110> b<109> b<108> b<107> b<106>
+b<105> b<104> b<103> b<102> b<101> b<100> b<99> b<98> b<97> b<96> b<95> b<94> b<93> b<92> b<91> b<90> b<89> b<88> b<87> b<86> b<85> b<84> b<83> b<82> b<81> b<80> b<79> b<78> b<77> b<76> b<75> b<74> b<73> b<72> b<71> b<70> b<69> b<68> b<67> b<66> b<65> b<64> b<63> b<62> b<61> b<60> b<59> b<58> b<57> b<56> b<55> b<54> b<53> b<52> b<51> b<50> b<49> b<48> b<47> b<46> b<45> b<44> b<43> b<42> b<41> b<40> b<39> b<38> b<37> b<36> b<35> b<34> b<33> b<32> b<31> b<30> b<29> b<28> b<27> b<26> b<25> b<24> b<23> b<22> b<21> b<20> b<19> b<18> b<17> b<16> b<15> b<14> b<13> b<12> b<11> b<10> b<9> b<8> b<7> b<6> b<5> b<4> b<3> b<2> b<1> b<0> SRAM_192
xi30 wl<5> b1<191> b1<190> b1<189> b1<188> b1<187> b1<186> b1<185> b1<184> b1<183> b1<182> b1<181> b1<180> b1<179> b1<178> b1<177> b1<176> b1<175> b1<174> b1<173> b1<172> b1<171> b1<170> b1<169> b1<168> b1<167> b1<166> b1<165> b1<164> b1<163> b1<162> b1<161> b1<160> b1<159> b1<158> b1<157> b1<156> b1<155> b1<154> b1<153> b1<152> b1<151> b1<150> b1<149> b1<148> b1<147> b1<146> b1<145> b1<144> b1<143> b1<142> b1<141> b1<140> b1<139> b1<138> b1<137> b1<136> b1<135> b1<134> b1<133> b1<132> b1<131> b1<130> b1<129> b1<128> b1<127> b1<126> b1<125> b1<124> b1<123> b1<122> b1<121> b1<120> b1<119> b1<118> b1<117> b1<116> b1<115> b1<114> b1<113> b1<112> b1<111> b1<110> b1<109> b1<108> b1<107> b1<106> b1<105> b1<104> b1<103> b1<102> b1<101> b1<100> b1<99> b1<98> b1<97> b1<96> b1<95> b1<94> b1<93> b1<92> b1<91> b1<90> b1<89> b1<88> b1<87> b1<86> b1<85> b1<84> b1<83> b1<82> b1<81> b1<80> b1<79> b1<78> b1<77> b1<76> b1<75> b1<74> b1<73> b1<72> b1<71> b1<70> b1<69> b1<68> b1<67> b1<66> b1<65> b1<64> b1<63> b1<62> b1<61>
+b1<60> b1<59> b1<58> b1<57> b1<56> b1<55> b1<54> b1<53> b1<52> b1<51> b1<50> b1<49> b1<48> b1<47> b1<46> b1<45> b1<44> b1<43> b1<42> b1<41> b1<40> b1<39> b1<38> b1<37> b1<36> b1<35> b1<34> b1<33> b1<32> b1<31> b1<30> b1<29> b1<28> b1<27> b1<26> b1<25> b1<24> b1<23> b1<22> b1<21> b1<20> b1<19> b1<18> b1<17> b1<16> b1<15> b1<14> b1<13> b1<12> b1<11> b1<10> b1<9> b1<8> b1<7> b1<6> b1<5> b1<4> b1<3> b1<2> b1<1> b1<0> b<191> b<190> b<189> b<188> b<187> b<186> b<185> b<184> b<183> b<182> b<181> b<180> b<179> b<178> b<177> b<176> b<175> b<174> b<173> b<172> b<171> b<170> b<169> b<168> b<167> b<166> b<165> b<164> b<163> b<162> b<161> b<160> b<159> b<158> b<157> b<156> b<155> b<154> b<153> b<152> b<151> b<150> b<149> b<148> b<147> b<146> b<145> b<144> b<143> b<142> b<141> b<140> b<139> b<138> b<137> b<136> b<135> b<134> b<133> b<132> b<131> b<130> b<129> b<128> b<127> b<126> b<125> b<124> b<123> b<122> b<121> b<120> b<119> b<118> b<117> b<116> b<115> b<114> b<113> b<112> b<111> b<110> b<109> b<108> b<107> b<106>
+b<105> b<104> b<103> b<102> b<101> b<100> b<99> b<98> b<97> b<96> b<95> b<94> b<93> b<92> b<91> b<90> b<89> b<88> b<87> b<86> b<85> b<84> b<83> b<82> b<81> b<80> b<79> b<78> b<77> b<76> b<75> b<74> b<73> b<72> b<71> b<70> b<69> b<68> b<67> b<66> b<65> b<64> b<63> b<62> b<61> b<60> b<59> b<58> b<57> b<56> b<55> b<54> b<53> b<52> b<51> b<50> b<49> b<48> b<47> b<46> b<45> b<44> b<43> b<42> b<41> b<40> b<39> b<38> b<37> b<36> b<35> b<34> b<33> b<32> b<31> b<30> b<29> b<28> b<27> b<26> b<25> b<24> b<23> b<22> b<21> b<20> b<19> b<18> b<17> b<16> b<15> b<14> b<13> b<12> b<11> b<10> b<9> b<8> b<7> b<6> b<5> b<4> b<3> b<2> b<1> b<0> SRAM_192
xi29 wl<6> b1<191> b1<190> b1<189> b1<188> b1<187> b1<186> b1<185> b1<184> b1<183> b1<182> b1<181> b1<180> b1<179> b1<178> b1<177> b1<176> b1<175> b1<174> b1<173> b1<172> b1<171> b1<170> b1<169> b1<168> b1<167> b1<166> b1<165> b1<164> b1<163> b1<162> b1<161> b1<160> b1<159> b1<158> b1<157> b1<156> b1<155> b1<154> b1<153> b1<152> b1<151> b1<150> b1<149> b1<148> b1<147> b1<146> b1<145> b1<144> b1<143> b1<142> b1<141> b1<140> b1<139> b1<138> b1<137> b1<136> b1<135> b1<134> b1<133> b1<132> b1<131> b1<130> b1<129> b1<128> b1<127> b1<126> b1<125> b1<124> b1<123> b1<122> b1<121> b1<120> b1<119> b1<118> b1<117> b1<116> b1<115> b1<114> b1<113> b1<112> b1<111> b1<110> b1<109> b1<108> b1<107> b1<106> b1<105> b1<104> b1<103> b1<102> b1<101> b1<100> b1<99> b1<98> b1<97> b1<96> b1<95> b1<94> b1<93> b1<92> b1<91> b1<90> b1<89> b1<88> b1<87> b1<86> b1<85> b1<84> b1<83> b1<82> b1<81> b1<80> b1<79> b1<78> b1<77> b1<76> b1<75> b1<74> b1<73> b1<72> b1<71> b1<70> b1<69> b1<68> b1<67> b1<66> b1<65> b1<64> b1<63> b1<62> b1<61>
+b1<60> b1<59> b1<58> b1<57> b1<56> b1<55> b1<54> b1<53> b1<52> b1<51> b1<50> b1<49> b1<48> b1<47> b1<46> b1<45> b1<44> b1<43> b1<42> b1<41> b1<40> b1<39> b1<38> b1<37> b1<36> b1<35> b1<34> b1<33> b1<32> b1<31> b1<30> b1<29> b1<28> b1<27> b1<26> b1<25> b1<24> b1<23> b1<22> b1<21> b1<20> b1<19> b1<18> b1<17> b1<16> b1<15> b1<14> b1<13> b1<12> b1<11> b1<10> b1<9> b1<8> b1<7> b1<6> b1<5> b1<4> b1<3> b1<2> b1<1> b1<0> b<191> b<190> b<189> b<188> b<187> b<186> b<185> b<184> b<183> b<182> b<181> b<180> b<179> b<178> b<177> b<176> b<175> b<174> b<173> b<172> b<171> b<170> b<169> b<168> b<167> b<166> b<165> b<164> b<163> b<162> b<161> b<160> b<159> b<158> b<157> b<156> b<155> b<154> b<153> b<152> b<151> b<150> b<149> b<148> b<147> b<146> b<145> b<144> b<143> b<142> b<141> b<140> b<139> b<138> b<137> b<136> b<135> b<134> b<133> b<132> b<131> b<130> b<129> b<128> b<127> b<126> b<125> b<124> b<123> b<122> b<121> b<120> b<119> b<118> b<117> b<116> b<115> b<114> b<113> b<112> b<111> b<110> b<109> b<108> b<107> b<106>
+b<105> b<104> b<103> b<102> b<101> b<100> b<99> b<98> b<97> b<96> b<95> b<94> b<93> b<92> b<91> b<90> b<89> b<88> b<87> b<86> b<85> b<84> b<83> b<82> b<81> b<80> b<79> b<78> b<77> b<76> b<75> b<74> b<73> b<72> b<71> b<70> b<69> b<68> b<67> b<66> b<65> b<64> b<63> b<62> b<61> b<60> b<59> b<58> b<57> b<56> b<55> b<54> b<53> b<52> b<51> b<50> b<49> b<48> b<47> b<46> b<45> b<44> b<43> b<42> b<41> b<40> b<39> b<38> b<37> b<36> b<35> b<34> b<33> b<32> b<31> b<30> b<29> b<28> b<27> b<26> b<25> b<24> b<23> b<22> b<21> b<20> b<19> b<18> b<17> b<16> b<15> b<14> b<13> b<12> b<11> b<10> b<9> b<8> b<7> b<6> b<5> b<4> b<3> b<2> b<1> b<0> SRAM_192
xi28 wl<7> b1<191> b1<190> b1<189> b1<188> b1<187> b1<186> b1<185> b1<184> b1<183> b1<182> b1<181> b1<180> b1<179> b1<178> b1<177> b1<176> b1<175> b1<174> b1<173> b1<172> b1<171> b1<170> b1<169> b1<168> b1<167> b1<166> b1<165> b1<164> b1<163> b1<162> b1<161> b1<160> b1<159> b1<158> b1<157> b1<156> b1<155> b1<154> b1<153> b1<152> b1<151> b1<150> b1<149> b1<148> b1<147> b1<146> b1<145> b1<144> b1<143> b1<142> b1<141> b1<140> b1<139> b1<138> b1<137> b1<136> b1<135> b1<134> b1<133> b1<132> b1<131> b1<130> b1<129> b1<128> b1<127> b1<126> b1<125> b1<124> b1<123> b1<122> b1<121> b1<120> b1<119> b1<118> b1<117> b1<116> b1<115> b1<114> b1<113> b1<112> b1<111> b1<110> b1<109> b1<108> b1<107> b1<106> b1<105> b1<104> b1<103> b1<102> b1<101> b1<100> b1<99> b1<98> b1<97> b1<96> b1<95> b1<94> b1<93> b1<92> b1<91> b1<90> b1<89> b1<88> b1<87> b1<86> b1<85> b1<84> b1<83> b1<82> b1<81> b1<80> b1<79> b1<78> b1<77> b1<76> b1<75> b1<74> b1<73> b1<72> b1<71> b1<70> b1<69> b1<68> b1<67> b1<66> b1<65> b1<64> b1<63> b1<62> b1<61>
+b1<60> b1<59> b1<58> b1<57> b1<56> b1<55> b1<54> b1<53> b1<52> b1<51> b1<50> b1<49> b1<48> b1<47> b1<46> b1<45> b1<44> b1<43> b1<42> b1<41> b1<40> b1<39> b1<38> b1<37> b1<36> b1<35> b1<34> b1<33> b1<32> b1<31> b1<30> b1<29> b1<28> b1<27> b1<26> b1<25> b1<24> b1<23> b1<22> b1<21> b1<20> b1<19> b1<18> b1<17> b1<16> b1<15> b1<14> b1<13> b1<12> b1<11> b1<10> b1<9> b1<8> b1<7> b1<6> b1<5> b1<4> b1<3> b1<2> b1<1> b1<0> b<191> b<190> b<189> b<188> b<187> b<186> b<185> b<184> b<183> b<182> b<181> b<180> b<179> b<178> b<177> b<176> b<175> b<174> b<173> b<172> b<171> b<170> b<169> b<168> b<167> b<166> b<165> b<164> b<163> b<162> b<161> b<160> b<159> b<158> b<157> b<156> b<155> b<154> b<153> b<152> b<151> b<150> b<149> b<148> b<147> b<146> b<145> b<144> b<143> b<142> b<141> b<140> b<139> b<138> b<137> b<136> b<135> b<134> b<133> b<132> b<131> b<130> b<129> b<128> b<127> b<126> b<125> b<124> b<123> b<122> b<121> b<120> b<119> b<118> b<117> b<116> b<115> b<114> b<113> b<112> b<111> b<110> b<109> b<108> b<107> b<106>
+b<105> b<104> b<103> b<102> b<101> b<100> b<99> b<98> b<97> b<96> b<95> b<94> b<93> b<92> b<91> b<90> b<89> b<88> b<87> b<86> b<85> b<84> b<83> b<82> b<81> b<80> b<79> b<78> b<77> b<76> b<75> b<74> b<73> b<72> b<71> b<70> b<69> b<68> b<67> b<66> b<65> b<64> b<63> b<62> b<61> b<60> b<59> b<58> b<57> b<56> b<55> b<54> b<53> b<52> b<51> b<50> b<49> b<48> b<47> b<46> b<45> b<44> b<43> b<42> b<41> b<40> b<39> b<38> b<37> b<36> b<35> b<34> b<33> b<32> b<31> b<30> b<29> b<28> b<27> b<26> b<25> b<24> b<23> b<22> b<21> b<20> b<19> b<18> b<17> b<16> b<15> b<14> b<13> b<12> b<11> b<10> b<9> b<8> b<7> b<6> b<5> b<4> b<3> b<2> b<1> b<0> SRAM_192
xi27 wl<8> b1<191> b1<190> b1<189> b1<188> b1<187> b1<186> b1<185> b1<184> b1<183> b1<182> b1<181> b1<180> b1<179> b1<178> b1<177> b1<176> b1<175> b1<174> b1<173> b1<172> b1<171> b1<170> b1<169> b1<168> b1<167> b1<166> b1<165> b1<164> b1<163> b1<162> b1<161> b1<160> b1<159> b1<158> b1<157> b1<156> b1<155> b1<154> b1<153> b1<152> b1<151> b1<150> b1<149> b1<148> b1<147> b1<146> b1<145> b1<144> b1<143> b1<142> b1<141> b1<140> b1<139> b1<138> b1<137> b1<136> b1<135> b1<134> b1<133> b1<132> b1<131> b1<130> b1<129> b1<128> b1<127> b1<126> b1<125> b1<124> b1<123> b1<122> b1<121> b1<120> b1<119> b1<118> b1<117> b1<116> b1<115> b1<114> b1<113> b1<112> b1<111> b1<110> b1<109> b1<108> b1<107> b1<106> b1<105> b1<104> b1<103> b1<102> b1<101> b1<100> b1<99> b1<98> b1<97> b1<96> b1<95> b1<94> b1<93> b1<92> b1<91> b1<90> b1<89> b1<88> b1<87> b1<86> b1<85> b1<84> b1<83> b1<82> b1<81> b1<80> b1<79> b1<78> b1<77> b1<76> b1<75> b1<74> b1<73> b1<72> b1<71> b1<70> b1<69> b1<68> b1<67> b1<66> b1<65> b1<64> b1<63> b1<62> b1<61>
+b1<60> b1<59> b1<58> b1<57> b1<56> b1<55> b1<54> b1<53> b1<52> b1<51> b1<50> b1<49> b1<48> b1<47> b1<46> b1<45> b1<44> b1<43> b1<42> b1<41> b1<40> b1<39> b1<38> b1<37> b1<36> b1<35> b1<34> b1<33> b1<32> b1<31> b1<30> b1<29> b1<28> b1<27> b1<26> b1<25> b1<24> b1<23> b1<22> b1<21> b1<20> b1<19> b1<18> b1<17> b1<16> b1<15> b1<14> b1<13> b1<12> b1<11> b1<10> b1<9> b1<8> b1<7> b1<6> b1<5> b1<4> b1<3> b1<2> b1<1> b1<0> b<191> b<190> b<189> b<188> b<187> b<186> b<185> b<184> b<183> b<182> b<181> b<180> b<179> b<178> b<177> b<176> b<175> b<174> b<173> b<172> b<171> b<170> b<169> b<168> b<167> b<166> b<165> b<164> b<163> b<162> b<161> b<160> b<159> b<158> b<157> b<156> b<155> b<154> b<153> b<152> b<151> b<150> b<149> b<148> b<147> b<146> b<145> b<144> b<143> b<142> b<141> b<140> b<139> b<138> b<137> b<136> b<135> b<134> b<133> b<132> b<131> b<130> b<129> b<128> b<127> b<126> b<125> b<124> b<123> b<122> b<121> b<120> b<119> b<118> b<117> b<116> b<115> b<114> b<113> b<112> b<111> b<110> b<109> b<108> b<107> b<106>
+b<105> b<104> b<103> b<102> b<101> b<100> b<99> b<98> b<97> b<96> b<95> b<94> b<93> b<92> b<91> b<90> b<89> b<88> b<87> b<86> b<85> b<84> b<83> b<82> b<81> b<80> b<79> b<78> b<77> b<76> b<75> b<74> b<73> b<72> b<71> b<70> b<69> b<68> b<67> b<66> b<65> b<64> b<63> b<62> b<61> b<60> b<59> b<58> b<57> b<56> b<55> b<54> b<53> b<52> b<51> b<50> b<49> b<48> b<47> b<46> b<45> b<44> b<43> b<42> b<41> b<40> b<39> b<38> b<37> b<36> b<35> b<34> b<33> b<32> b<31> b<30> b<29> b<28> b<27> b<26> b<25> b<24> b<23> b<22> b<21> b<20> b<19> b<18> b<17> b<16> b<15> b<14> b<13> b<12> b<11> b<10> b<9> b<8> b<7> b<6> b<5> b<4> b<3> b<2> b<1> b<0> SRAM_192
xi26 wl<9> b1<191> b1<190> b1<189> b1<188> b1<187> b1<186> b1<185> b1<184> b1<183> b1<182> b1<181> b1<180> b1<179> b1<178> b1<177> b1<176> b1<175> b1<174> b1<173> b1<172> b1<171> b1<170> b1<169> b1<168> b1<167> b1<166> b1<165> b1<164> b1<163> b1<162> b1<161> b1<160> b1<159> b1<158> b1<157> b1<156> b1<155> b1<154> b1<153> b1<152> b1<151> b1<150> b1<149> b1<148> b1<147> b1<146> b1<145> b1<144> b1<143> b1<142> b1<141> b1<140> b1<139> b1<138> b1<137> b1<136> b1<135> b1<134> b1<133> b1<132> b1<131> b1<130> b1<129> b1<128> b1<127> b1<126> b1<125> b1<124> b1<123> b1<122> b1<121> b1<120> b1<119> b1<118> b1<117> b1<116> b1<115> b1<114> b1<113> b1<112> b1<111> b1<110> b1<109> b1<108> b1<107> b1<106> b1<105> b1<104> b1<103> b1<102> b1<101> b1<100> b1<99> b1<98> b1<97> b1<96> b1<95> b1<94> b1<93> b1<92> b1<91> b1<90> b1<89> b1<88> b1<87> b1<86> b1<85> b1<84> b1<83> b1<82> b1<81> b1<80> b1<79> b1<78> b1<77> b1<76> b1<75> b1<74> b1<73> b1<72> b1<71> b1<70> b1<69> b1<68> b1<67> b1<66> b1<65> b1<64> b1<63> b1<62> b1<61>
+b1<60> b1<59> b1<58> b1<57> b1<56> b1<55> b1<54> b1<53> b1<52> b1<51> b1<50> b1<49> b1<48> b1<47> b1<46> b1<45> b1<44> b1<43> b1<42> b1<41> b1<40> b1<39> b1<38> b1<37> b1<36> b1<35> b1<34> b1<33> b1<32> b1<31> b1<30> b1<29> b1<28> b1<27> b1<26> b1<25> b1<24> b1<23> b1<22> b1<21> b1<20> b1<19> b1<18> b1<17> b1<16> b1<15> b1<14> b1<13> b1<12> b1<11> b1<10> b1<9> b1<8> b1<7> b1<6> b1<5> b1<4> b1<3> b1<2> b1<1> b1<0> b<191> b<190> b<189> b<188> b<187> b<186> b<185> b<184> b<183> b<182> b<181> b<180> b<179> b<178> b<177> b<176> b<175> b<174> b<173> b<172> b<171> b<170> b<169> b<168> b<167> b<166> b<165> b<164> b<163> b<162> b<161> b<160> b<159> b<158> b<157> b<156> b<155> b<154> b<153> b<152> b<151> b<150> b<149> b<148> b<147> b<146> b<145> b<144> b<143> b<142> b<141> b<140> b<139> b<138> b<137> b<136> b<135> b<134> b<133> b<132> b<131> b<130> b<129> b<128> b<127> b<126> b<125> b<124> b<123> b<122> b<121> b<120> b<119> b<118> b<117> b<116> b<115> b<114> b<113> b<112> b<111> b<110> b<109> b<108> b<107> b<106>
+b<105> b<104> b<103> b<102> b<101> b<100> b<99> b<98> b<97> b<96> b<95> b<94> b<93> b<92> b<91> b<90> b<89> b<88> b<87> b<86> b<85> b<84> b<83> b<82> b<81> b<80> b<79> b<78> b<77> b<76> b<75> b<74> b<73> b<72> b<71> b<70> b<69> b<68> b<67> b<66> b<65> b<64> b<63> b<62> b<61> b<60> b<59> b<58> b<57> b<56> b<55> b<54> b<53> b<52> b<51> b<50> b<49> b<48> b<47> b<46> b<45> b<44> b<43> b<42> b<41> b<40> b<39> b<38> b<37> b<36> b<35> b<34> b<33> b<32> b<31> b<30> b<29> b<28> b<27> b<26> b<25> b<24> b<23> b<22> b<21> b<20> b<19> b<18> b<17> b<16> b<15> b<14> b<13> b<12> b<11> b<10> b<9> b<8> b<7> b<6> b<5> b<4> b<3> b<2> b<1> b<0> SRAM_192
xi25 wl<10> b1<191> b1<190> b1<189> b1<188> b1<187> b1<186> b1<185> b1<184> b1<183> b1<182> b1<181> b1<180> b1<179> b1<178> b1<177> b1<176> b1<175> b1<174> b1<173> b1<172> b1<171> b1<170> b1<169> b1<168> b1<167> b1<166> b1<165> b1<164> b1<163> b1<162> b1<161> b1<160> b1<159> b1<158> b1<157> b1<156> b1<155> b1<154> b1<153> b1<152> b1<151> b1<150> b1<149> b1<148> b1<147> b1<146> b1<145> b1<144> b1<143> b1<142> b1<141> b1<140> b1<139> b1<138> b1<137> b1<136> b1<135> b1<134> b1<133> b1<132> b1<131> b1<130> b1<129> b1<128> b1<127> b1<126> b1<125> b1<124> b1<123> b1<122> b1<121> b1<120> b1<119> b1<118> b1<117> b1<116> b1<115> b1<114> b1<113> b1<112> b1<111> b1<110> b1<109> b1<108> b1<107> b1<106> b1<105> b1<104> b1<103> b1<102> b1<101> b1<100> b1<99> b1<98> b1<97> b1<96> b1<95> b1<94> b1<93> b1<92> b1<91> b1<90> b1<89> b1<88> b1<87> b1<86> b1<85> b1<84> b1<83> b1<82> b1<81> b1<80> b1<79> b1<78> b1<77> b1<76> b1<75> b1<74> b1<73> b1<72> b1<71> b1<70> b1<69> b1<68> b1<67> b1<66> b1<65> b1<64> b1<63> b1<62> b1<61>
+b1<60> b1<59> b1<58> b1<57> b1<56> b1<55> b1<54> b1<53> b1<52> b1<51> b1<50> b1<49> b1<48> b1<47> b1<46> b1<45> b1<44> b1<43> b1<42> b1<41> b1<40> b1<39> b1<38> b1<37> b1<36> b1<35> b1<34> b1<33> b1<32> b1<31> b1<30> b1<29> b1<28> b1<27> b1<26> b1<25> b1<24> b1<23> b1<22> b1<21> b1<20> b1<19> b1<18> b1<17> b1<16> b1<15> b1<14> b1<13> b1<12> b1<11> b1<10> b1<9> b1<8> b1<7> b1<6> b1<5> b1<4> b1<3> b1<2> b1<1> b1<0> b<191> b<190> b<189> b<188> b<187> b<186> b<185> b<184> b<183> b<182> b<181> b<180> b<179> b<178> b<177> b<176> b<175> b<174> b<173> b<172> b<171> b<170> b<169> b<168> b<167> b<166> b<165> b<164> b<163> b<162> b<161> b<160> b<159> b<158> b<157> b<156> b<155> b<154> b<153> b<152> b<151> b<150> b<149> b<148> b<147> b<146> b<145> b<144> b<143> b<142> b<141> b<140> b<139> b<138> b<137> b<136> b<135> b<134> b<133> b<132> b<131> b<130> b<129> b<128> b<127> b<126> b<125> b<124> b<123> b<122> b<121> b<120> b<119> b<118> b<117> b<116> b<115> b<114> b<113> b<112> b<111> b<110> b<109> b<108> b<107> b<106>
+b<105> b<104> b<103> b<102> b<101> b<100> b<99> b<98> b<97> b<96> b<95> b<94> b<93> b<92> b<91> b<90> b<89> b<88> b<87> b<86> b<85> b<84> b<83> b<82> b<81> b<80> b<79> b<78> b<77> b<76> b<75> b<74> b<73> b<72> b<71> b<70> b<69> b<68> b<67> b<66> b<65> b<64> b<63> b<62> b<61> b<60> b<59> b<58> b<57> b<56> b<55> b<54> b<53> b<52> b<51> b<50> b<49> b<48> b<47> b<46> b<45> b<44> b<43> b<42> b<41> b<40> b<39> b<38> b<37> b<36> b<35> b<34> b<33> b<32> b<31> b<30> b<29> b<28> b<27> b<26> b<25> b<24> b<23> b<22> b<21> b<20> b<19> b<18> b<17> b<16> b<15> b<14> b<13> b<12> b<11> b<10> b<9> b<8> b<7> b<6> b<5> b<4> b<3> b<2> b<1> b<0> SRAM_192
xi24 wl<11> b1<191> b1<190> b1<189> b1<188> b1<187> b1<186> b1<185> b1<184> b1<183> b1<182> b1<181> b1<180> b1<179> b1<178> b1<177> b1<176> b1<175> b1<174> b1<173> b1<172> b1<171> b1<170> b1<169> b1<168> b1<167> b1<166> b1<165> b1<164> b1<163> b1<162> b1<161> b1<160> b1<159> b1<158> b1<157> b1<156> b1<155> b1<154> b1<153> b1<152> b1<151> b1<150> b1<149> b1<148> b1<147> b1<146> b1<145> b1<144> b1<143> b1<142> b1<141> b1<140> b1<139> b1<138> b1<137> b1<136> b1<135> b1<134> b1<133> b1<132> b1<131> b1<130> b1<129> b1<128> b1<127> b1<126> b1<125> b1<124> b1<123> b1<122> b1<121> b1<120> b1<119> b1<118> b1<117> b1<116> b1<115> b1<114> b1<113> b1<112> b1<111> b1<110> b1<109> b1<108> b1<107> b1<106> b1<105> b1<104> b1<103> b1<102> b1<101> b1<100> b1<99> b1<98> b1<97> b1<96> b1<95> b1<94> b1<93> b1<92> b1<91> b1<90> b1<89> b1<88> b1<87> b1<86> b1<85> b1<84> b1<83> b1<82> b1<81> b1<80> b1<79> b1<78> b1<77> b1<76> b1<75> b1<74> b1<73> b1<72> b1<71> b1<70> b1<69> b1<68> b1<67> b1<66> b1<65> b1<64> b1<63> b1<62> b1<61>
+b1<60> b1<59> b1<58> b1<57> b1<56> b1<55> b1<54> b1<53> b1<52> b1<51> b1<50> b1<49> b1<48> b1<47> b1<46> b1<45> b1<44> b1<43> b1<42> b1<41> b1<40> b1<39> b1<38> b1<37> b1<36> b1<35> b1<34> b1<33> b1<32> b1<31> b1<30> b1<29> b1<28> b1<27> b1<26> b1<25> b1<24> b1<23> b1<22> b1<21> b1<20> b1<19> b1<18> b1<17> b1<16> b1<15> b1<14> b1<13> b1<12> b1<11> b1<10> b1<9> b1<8> b1<7> b1<6> b1<5> b1<4> b1<3> b1<2> b1<1> b1<0> b<191> b<190> b<189> b<188> b<187> b<186> b<185> b<184> b<183> b<182> b<181> b<180> b<179> b<178> b<177> b<176> b<175> b<174> b<173> b<172> b<171> b<170> b<169> b<168> b<167> b<166> b<165> b<164> b<163> b<162> b<161> b<160> b<159> b<158> b<157> b<156> b<155> b<154> b<153> b<152> b<151> b<150> b<149> b<148> b<147> b<146> b<145> b<144> b<143> b<142> b<141> b<140> b<139> b<138> b<137> b<136> b<135> b<134> b<133> b<132> b<131> b<130> b<129> b<128> b<127> b<126> b<125> b<124> b<123> b<122> b<121> b<120> b<119> b<118> b<117> b<116> b<115> b<114> b<113> b<112> b<111> b<110> b<109> b<108> b<107> b<106>
+b<105> b<104> b<103> b<102> b<101> b<100> b<99> b<98> b<97> b<96> b<95> b<94> b<93> b<92> b<91> b<90> b<89> b<88> b<87> b<86> b<85> b<84> b<83> b<82> b<81> b<80> b<79> b<78> b<77> b<76> b<75> b<74> b<73> b<72> b<71> b<70> b<69> b<68> b<67> b<66> b<65> b<64> b<63> b<62> b<61> b<60> b<59> b<58> b<57> b<56> b<55> b<54> b<53> b<52> b<51> b<50> b<49> b<48> b<47> b<46> b<45> b<44> b<43> b<42> b<41> b<40> b<39> b<38> b<37> b<36> b<35> b<34> b<33> b<32> b<31> b<30> b<29> b<28> b<27> b<26> b<25> b<24> b<23> b<22> b<21> b<20> b<19> b<18> b<17> b<16> b<15> b<14> b<13> b<12> b<11> b<10> b<9> b<8> b<7> b<6> b<5> b<4> b<3> b<2> b<1> b<0> SRAM_192
xi23 wl<12> b1<191> b1<190> b1<189> b1<188> b1<187> b1<186> b1<185> b1<184> b1<183> b1<182> b1<181> b1<180> b1<179> b1<178> b1<177> b1<176> b1<175> b1<174> b1<173> b1<172> b1<171> b1<170> b1<169> b1<168> b1<167> b1<166> b1<165> b1<164> b1<163> b1<162> b1<161> b1<160> b1<159> b1<158> b1<157> b1<156> b1<155> b1<154> b1<153> b1<152> b1<151> b1<150> b1<149> b1<148> b1<147> b1<146> b1<145> b1<144> b1<143> b1<142> b1<141> b1<140> b1<139> b1<138> b1<137> b1<136> b1<135> b1<134> b1<133> b1<132> b1<131> b1<130> b1<129> b1<128> b1<127> b1<126> b1<125> b1<124> b1<123> b1<122> b1<121> b1<120> b1<119> b1<118> b1<117> b1<116> b1<115> b1<114> b1<113> b1<112> b1<111> b1<110> b1<109> b1<108> b1<107> b1<106> b1<105> b1<104> b1<103> b1<102> b1<101> b1<100> b1<99> b1<98> b1<97> b1<96> b1<95> b1<94> b1<93> b1<92> b1<91> b1<90> b1<89> b1<88> b1<87> b1<86> b1<85> b1<84> b1<83> b1<82> b1<81> b1<80> b1<79> b1<78> b1<77> b1<76> b1<75> b1<74> b1<73> b1<72> b1<71> b1<70> b1<69> b1<68> b1<67> b1<66> b1<65> b1<64> b1<63> b1<62> b1<61>
+b1<60> b1<59> b1<58> b1<57> b1<56> b1<55> b1<54> b1<53> b1<52> b1<51> b1<50> b1<49> b1<48> b1<47> b1<46> b1<45> b1<44> b1<43> b1<42> b1<41> b1<40> b1<39> b1<38> b1<37> b1<36> b1<35> b1<34> b1<33> b1<32> b1<31> b1<30> b1<29> b1<28> b1<27> b1<26> b1<25> b1<24> b1<23> b1<22> b1<21> b1<20> b1<19> b1<18> b1<17> b1<16> b1<15> b1<14> b1<13> b1<12> b1<11> b1<10> b1<9> b1<8> b1<7> b1<6> b1<5> b1<4> b1<3> b1<2> b1<1> b1<0> b<191> b<190> b<189> b<188> b<187> b<186> b<185> b<184> b<183> b<182> b<181> b<180> b<179> b<178> b<177> b<176> b<175> b<174> b<173> b<172> b<171> b<170> b<169> b<168> b<167> b<166> b<165> b<164> b<163> b<162> b<161> b<160> b<159> b<158> b<157> b<156> b<155> b<154> b<153> b<152> b<151> b<150> b<149> b<148> b<147> b<146> b<145> b<144> b<143> b<142> b<141> b<140> b<139> b<138> b<137> b<136> b<135> b<134> b<133> b<132> b<131> b<130> b<129> b<128> b<127> b<126> b<125> b<124> b<123> b<122> b<121> b<120> b<119> b<118> b<117> b<116> b<115> b<114> b<113> b<112> b<111> b<110> b<109> b<108> b<107> b<106>
+b<105> b<104> b<103> b<102> b<101> b<100> b<99> b<98> b<97> b<96> b<95> b<94> b<93> b<92> b<91> b<90> b<89> b<88> b<87> b<86> b<85> b<84> b<83> b<82> b<81> b<80> b<79> b<78> b<77> b<76> b<75> b<74> b<73> b<72> b<71> b<70> b<69> b<68> b<67> b<66> b<65> b<64> b<63> b<62> b<61> b<60> b<59> b<58> b<57> b<56> b<55> b<54> b<53> b<52> b<51> b<50> b<49> b<48> b<47> b<46> b<45> b<44> b<43> b<42> b<41> b<40> b<39> b<38> b<37> b<36> b<35> b<34> b<33> b<32> b<31> b<30> b<29> b<28> b<27> b<26> b<25> b<24> b<23> b<22> b<21> b<20> b<19> b<18> b<17> b<16> b<15> b<14> b<13> b<12> b<11> b<10> b<9> b<8> b<7> b<6> b<5> b<4> b<3> b<2> b<1> b<0> SRAM_192
xi22 wl<13> b1<191> b1<190> b1<189> b1<188> b1<187> b1<186> b1<185> b1<184> b1<183> b1<182> b1<181> b1<180> b1<179> b1<178> b1<177> b1<176> b1<175> b1<174> b1<173> b1<172> b1<171> b1<170> b1<169> b1<168> b1<167> b1<166> b1<165> b1<164> b1<163> b1<162> b1<161> b1<160> b1<159> b1<158> b1<157> b1<156> b1<155> b1<154> b1<153> b1<152> b1<151> b1<150> b1<149> b1<148> b1<147> b1<146> b1<145> b1<144> b1<143> b1<142> b1<141> b1<140> b1<139> b1<138> b1<137> b1<136> b1<135> b1<134> b1<133> b1<132> b1<131> b1<130> b1<129> b1<128> b1<127> b1<126> b1<125> b1<124> b1<123> b1<122> b1<121> b1<120> b1<119> b1<118> b1<117> b1<116> b1<115> b1<114> b1<113> b1<112> b1<111> b1<110> b1<109> b1<108> b1<107> b1<106> b1<105> b1<104> b1<103> b1<102> b1<101> b1<100> b1<99> b1<98> b1<97> b1<96> b1<95> b1<94> b1<93> b1<92> b1<91> b1<90> b1<89> b1<88> b1<87> b1<86> b1<85> b1<84> b1<83> b1<82> b1<81> b1<80> b1<79> b1<78> b1<77> b1<76> b1<75> b1<74> b1<73> b1<72> b1<71> b1<70> b1<69> b1<68> b1<67> b1<66> b1<65> b1<64> b1<63> b1<62> b1<61>
+b1<60> b1<59> b1<58> b1<57> b1<56> b1<55> b1<54> b1<53> b1<52> b1<51> b1<50> b1<49> b1<48> b1<47> b1<46> b1<45> b1<44> b1<43> b1<42> b1<41> b1<40> b1<39> b1<38> b1<37> b1<36> b1<35> b1<34> b1<33> b1<32> b1<31> b1<30> b1<29> b1<28> b1<27> b1<26> b1<25> b1<24> b1<23> b1<22> b1<21> b1<20> b1<19> b1<18> b1<17> b1<16> b1<15> b1<14> b1<13> b1<12> b1<11> b1<10> b1<9> b1<8> b1<7> b1<6> b1<5> b1<4> b1<3> b1<2> b1<1> b1<0> b<191> b<190> b<189> b<188> b<187> b<186> b<185> b<184> b<183> b<182> b<181> b<180> b<179> b<178> b<177> b<176> b<175> b<174> b<173> b<172> b<171> b<170> b<169> b<168> b<167> b<166> b<165> b<164> b<163> b<162> b<161> b<160> b<159> b<158> b<157> b<156> b<155> b<154> b<153> b<152> b<151> b<150> b<149> b<148> b<147> b<146> b<145> b<144> b<143> b<142> b<141> b<140> b<139> b<138> b<137> b<136> b<135> b<134> b<133> b<132> b<131> b<130> b<129> b<128> b<127> b<126> b<125> b<124> b<123> b<122> b<121> b<120> b<119> b<118> b<117> b<116> b<115> b<114> b<113> b<112> b<111> b<110> b<109> b<108> b<107> b<106>
+b<105> b<104> b<103> b<102> b<101> b<100> b<99> b<98> b<97> b<96> b<95> b<94> b<93> b<92> b<91> b<90> b<89> b<88> b<87> b<86> b<85> b<84> b<83> b<82> b<81> b<80> b<79> b<78> b<77> b<76> b<75> b<74> b<73> b<72> b<71> b<70> b<69> b<68> b<67> b<66> b<65> b<64> b<63> b<62> b<61> b<60> b<59> b<58> b<57> b<56> b<55> b<54> b<53> b<52> b<51> b<50> b<49> b<48> b<47> b<46> b<45> b<44> b<43> b<42> b<41> b<40> b<39> b<38> b<37> b<36> b<35> b<34> b<33> b<32> b<31> b<30> b<29> b<28> b<27> b<26> b<25> b<24> b<23> b<22> b<21> b<20> b<19> b<18> b<17> b<16> b<15> b<14> b<13> b<12> b<11> b<10> b<9> b<8> b<7> b<6> b<5> b<4> b<3> b<2> b<1> b<0> SRAM_192
xi21 wl<14> b1<191> b1<190> b1<189> b1<188> b1<187> b1<186> b1<185> b1<184> b1<183> b1<182> b1<181> b1<180> b1<179> b1<178> b1<177> b1<176> b1<175> b1<174> b1<173> b1<172> b1<171> b1<170> b1<169> b1<168> b1<167> b1<166> b1<165> b1<164> b1<163> b1<162> b1<161> b1<160> b1<159> b1<158> b1<157> b1<156> b1<155> b1<154> b1<153> b1<152> b1<151> b1<150> b1<149> b1<148> b1<147> b1<146> b1<145> b1<144> b1<143> b1<142> b1<141> b1<140> b1<139> b1<138> b1<137> b1<136> b1<135> b1<134> b1<133> b1<132> b1<131> b1<130> b1<129> b1<128> b1<127> b1<126> b1<125> b1<124> b1<123> b1<122> b1<121> b1<120> b1<119> b1<118> b1<117> b1<116> b1<115> b1<114> b1<113> b1<112> b1<111> b1<110> b1<109> b1<108> b1<107> b1<106> b1<105> b1<104> b1<103> b1<102> b1<101> b1<100> b1<99> b1<98> b1<97> b1<96> b1<95> b1<94> b1<93> b1<92> b1<91> b1<90> b1<89> b1<88> b1<87> b1<86> b1<85> b1<84> b1<83> b1<82> b1<81> b1<80> b1<79> b1<78> b1<77> b1<76> b1<75> b1<74> b1<73> b1<72> b1<71> b1<70> b1<69> b1<68> b1<67> b1<66> b1<65> b1<64> b1<63> b1<62> b1<61>
+b1<60> b1<59> b1<58> b1<57> b1<56> b1<55> b1<54> b1<53> b1<52> b1<51> b1<50> b1<49> b1<48> b1<47> b1<46> b1<45> b1<44> b1<43> b1<42> b1<41> b1<40> b1<39> b1<38> b1<37> b1<36> b1<35> b1<34> b1<33> b1<32> b1<31> b1<30> b1<29> b1<28> b1<27> b1<26> b1<25> b1<24> b1<23> b1<22> b1<21> b1<20> b1<19> b1<18> b1<17> b1<16> b1<15> b1<14> b1<13> b1<12> b1<11> b1<10> b1<9> b1<8> b1<7> b1<6> b1<5> b1<4> b1<3> b1<2> b1<1> b1<0> b<191> b<190> b<189> b<188> b<187> b<186> b<185> b<184> b<183> b<182> b<181> b<180> b<179> b<178> b<177> b<176> b<175> b<174> b<173> b<172> b<171> b<170> b<169> b<168> b<167> b<166> b<165> b<164> b<163> b<162> b<161> b<160> b<159> b<158> b<157> b<156> b<155> b<154> b<153> b<152> b<151> b<150> b<149> b<148> b<147> b<146> b<145> b<144> b<143> b<142> b<141> b<140> b<139> b<138> b<137> b<136> b<135> b<134> b<133> b<132> b<131> b<130> b<129> b<128> b<127> b<126> b<125> b<124> b<123> b<122> b<121> b<120> b<119> b<118> b<117> b<116> b<115> b<114> b<113> b<112> b<111> b<110> b<109> b<108> b<107> b<106>
+b<105> b<104> b<103> b<102> b<101> b<100> b<99> b<98> b<97> b<96> b<95> b<94> b<93> b<92> b<91> b<90> b<89> b<88> b<87> b<86> b<85> b<84> b<83> b<82> b<81> b<80> b<79> b<78> b<77> b<76> b<75> b<74> b<73> b<72> b<71> b<70> b<69> b<68> b<67> b<66> b<65> b<64> b<63> b<62> b<61> b<60> b<59> b<58> b<57> b<56> b<55> b<54> b<53> b<52> b<51> b<50> b<49> b<48> b<47> b<46> b<45> b<44> b<43> b<42> b<41> b<40> b<39> b<38> b<37> b<36> b<35> b<34> b<33> b<32> b<31> b<30> b<29> b<28> b<27> b<26> b<25> b<24> b<23> b<22> b<21> b<20> b<19> b<18> b<17> b<16> b<15> b<14> b<13> b<12> b<11> b<10> b<9> b<8> b<7> b<6> b<5> b<4> b<3> b<2> b<1> b<0> SRAM_192
xi20 wl<15> b1<191> b1<190> b1<189> b1<188> b1<187> b1<186> b1<185> b1<184> b1<183> b1<182> b1<181> b1<180> b1<179> b1<178> b1<177> b1<176> b1<175> b1<174> b1<173> b1<172> b1<171> b1<170> b1<169> b1<168> b1<167> b1<166> b1<165> b1<164> b1<163> b1<162> b1<161> b1<160> b1<159> b1<158> b1<157> b1<156> b1<155> b1<154> b1<153> b1<152> b1<151> b1<150> b1<149> b1<148> b1<147> b1<146> b1<145> b1<144> b1<143> b1<142> b1<141> b1<140> b1<139> b1<138> b1<137> b1<136> b1<135> b1<134> b1<133> b1<132> b1<131> b1<130> b1<129> b1<128> b1<127> b1<126> b1<125> b1<124> b1<123> b1<122> b1<121> b1<120> b1<119> b1<118> b1<117> b1<116> b1<115> b1<114> b1<113> b1<112> b1<111> b1<110> b1<109> b1<108> b1<107> b1<106> b1<105> b1<104> b1<103> b1<102> b1<101> b1<100> b1<99> b1<98> b1<97> b1<96> b1<95> b1<94> b1<93> b1<92> b1<91> b1<90> b1<89> b1<88> b1<87> b1<86> b1<85> b1<84> b1<83> b1<82> b1<81> b1<80> b1<79> b1<78> b1<77> b1<76> b1<75> b1<74> b1<73> b1<72> b1<71> b1<70> b1<69> b1<68> b1<67> b1<66> b1<65> b1<64> b1<63> b1<62> b1<61>
+b1<60> b1<59> b1<58> b1<57> b1<56> b1<55> b1<54> b1<53> b1<52> b1<51> b1<50> b1<49> b1<48> b1<47> b1<46> b1<45> b1<44> b1<43> b1<42> b1<41> b1<40> b1<39> b1<38> b1<37> b1<36> b1<35> b1<34> b1<33> b1<32> b1<31> b1<30> b1<29> b1<28> b1<27> b1<26> b1<25> b1<24> b1<23> b1<22> b1<21> b1<20> b1<19> b1<18> b1<17> b1<16> b1<15> b1<14> b1<13> b1<12> b1<11> b1<10> b1<9> b1<8> b1<7> b1<6> b1<5> b1<4> b1<3> b1<2> b1<1> b1<0> b<191> b<190> b<189> b<188> b<187> b<186> b<185> b<184> b<183> b<182> b<181> b<180> b<179> b<178> b<177> b<176> b<175> b<174> b<173> b<172> b<171> b<170> b<169> b<168> b<167> b<166> b<165> b<164> b<163> b<162> b<161> b<160> b<159> b<158> b<157> b<156> b<155> b<154> b<153> b<152> b<151> b<150> b<149> b<148> b<147> b<146> b<145> b<144> b<143> b<142> b<141> b<140> b<139> b<138> b<137> b<136> b<135> b<134> b<133> b<132> b<131> b<130> b<129> b<128> b<127> b<126> b<125> b<124> b<123> b<122> b<121> b<120> b<119> b<118> b<117> b<116> b<115> b<114> b<113> b<112> b<111> b<110> b<109> b<108> b<107> b<106>
+b<105> b<104> b<103> b<102> b<101> b<100> b<99> b<98> b<97> b<96> b<95> b<94> b<93> b<92> b<91> b<90> b<89> b<88> b<87> b<86> b<85> b<84> b<83> b<82> b<81> b<80> b<79> b<78> b<77> b<76> b<75> b<74> b<73> b<72> b<71> b<70> b<69> b<68> b<67> b<66> b<65> b<64> b<63> b<62> b<61> b<60> b<59> b<58> b<57> b<56> b<55> b<54> b<53> b<52> b<51> b<50> b<49> b<48> b<47> b<46> b<45> b<44> b<43> b<42> b<41> b<40> b<39> b<38> b<37> b<36> b<35> b<34> b<33> b<32> b<31> b<30> b<29> b<28> b<27> b<26> b<25> b<24> b<23> b<22> b<21> b<20> b<19> b<18> b<17> b<16> b<15> b<14> b<13> b<12> b<11> b<10> b<9> b<8> b<7> b<6> b<5> b<4> b<3> b<2> b<1> b<0> SRAM_192
xi19 wl<16> b1<191> b1<190> b1<189> b1<188> b1<187> b1<186> b1<185> b1<184> b1<183> b1<182> b1<181> b1<180> b1<179> b1<178> b1<177> b1<176> b1<175> b1<174> b1<173> b1<172> b1<171> b1<170> b1<169> b1<168> b1<167> b1<166> b1<165> b1<164> b1<163> b1<162> b1<161> b1<160> b1<159> b1<158> b1<157> b1<156> b1<155> b1<154> b1<153> b1<152> b1<151> b1<150> b1<149> b1<148> b1<147> b1<146> b1<145> b1<144> b1<143> b1<142> b1<141> b1<140> b1<139> b1<138> b1<137> b1<136> b1<135> b1<134> b1<133> b1<132> b1<131> b1<130> b1<129> b1<128> b1<127> b1<126> b1<125> b1<124> b1<123> b1<122> b1<121> b1<120> b1<119> b1<118> b1<117> b1<116> b1<115> b1<114> b1<113> b1<112> b1<111> b1<110> b1<109> b1<108> b1<107> b1<106> b1<105> b1<104> b1<103> b1<102> b1<101> b1<100> b1<99> b1<98> b1<97> b1<96> b1<95> b1<94> b1<93> b1<92> b1<91> b1<90> b1<89> b1<88> b1<87> b1<86> b1<85> b1<84> b1<83> b1<82> b1<81> b1<80> b1<79> b1<78> b1<77> b1<76> b1<75> b1<74> b1<73> b1<72> b1<71> b1<70> b1<69> b1<68> b1<67> b1<66> b1<65> b1<64> b1<63> b1<62> b1<61>
+b1<60> b1<59> b1<58> b1<57> b1<56> b1<55> b1<54> b1<53> b1<52> b1<51> b1<50> b1<49> b1<48> b1<47> b1<46> b1<45> b1<44> b1<43> b1<42> b1<41> b1<40> b1<39> b1<38> b1<37> b1<36> b1<35> b1<34> b1<33> b1<32> b1<31> b1<30> b1<29> b1<28> b1<27> b1<26> b1<25> b1<24> b1<23> b1<22> b1<21> b1<20> b1<19> b1<18> b1<17> b1<16> b1<15> b1<14> b1<13> b1<12> b1<11> b1<10> b1<9> b1<8> b1<7> b1<6> b1<5> b1<4> b1<3> b1<2> b1<1> b1<0> b<191> b<190> b<189> b<188> b<187> b<186> b<185> b<184> b<183> b<182> b<181> b<180> b<179> b<178> b<177> b<176> b<175> b<174> b<173> b<172> b<171> b<170> b<169> b<168> b<167> b<166> b<165> b<164> b<163> b<162> b<161> b<160> b<159> b<158> b<157> b<156> b<155> b<154> b<153> b<152> b<151> b<150> b<149> b<148> b<147> b<146> b<145> b<144> b<143> b<142> b<141> b<140> b<139> b<138> b<137> b<136> b<135> b<134> b<133> b<132> b<131> b<130> b<129> b<128> b<127> b<126> b<125> b<124> b<123> b<122> b<121> b<120> b<119> b<118> b<117> b<116> b<115> b<114> b<113> b<112> b<111> b<110> b<109> b<108> b<107> b<106>
+b<105> b<104> b<103> b<102> b<101> b<100> b<99> b<98> b<97> b<96> b<95> b<94> b<93> b<92> b<91> b<90> b<89> b<88> b<87> b<86> b<85> b<84> b<83> b<82> b<81> b<80> b<79> b<78> b<77> b<76> b<75> b<74> b<73> b<72> b<71> b<70> b<69> b<68> b<67> b<66> b<65> b<64> b<63> b<62> b<61> b<60> b<59> b<58> b<57> b<56> b<55> b<54> b<53> b<52> b<51> b<50> b<49> b<48> b<47> b<46> b<45> b<44> b<43> b<42> b<41> b<40> b<39> b<38> b<37> b<36> b<35> b<34> b<33> b<32> b<31> b<30> b<29> b<28> b<27> b<26> b<25> b<24> b<23> b<22> b<21> b<20> b<19> b<18> b<17> b<16> b<15> b<14> b<13> b<12> b<11> b<10> b<9> b<8> b<7> b<6> b<5> b<4> b<3> b<2> b<1> b<0> SRAM_192
xi18 wl<17> b1<191> b1<190> b1<189> b1<188> b1<187> b1<186> b1<185> b1<184> b1<183> b1<182> b1<181> b1<180> b1<179> b1<178> b1<177> b1<176> b1<175> b1<174> b1<173> b1<172> b1<171> b1<170> b1<169> b1<168> b1<167> b1<166> b1<165> b1<164> b1<163> b1<162> b1<161> b1<160> b1<159> b1<158> b1<157> b1<156> b1<155> b1<154> b1<153> b1<152> b1<151> b1<150> b1<149> b1<148> b1<147> b1<146> b1<145> b1<144> b1<143> b1<142> b1<141> b1<140> b1<139> b1<138> b1<137> b1<136> b1<135> b1<134> b1<133> b1<132> b1<131> b1<130> b1<129> b1<128> b1<127> b1<126> b1<125> b1<124> b1<123> b1<122> b1<121> b1<120> b1<119> b1<118> b1<117> b1<116> b1<115> b1<114> b1<113> b1<112> b1<111> b1<110> b1<109> b1<108> b1<107> b1<106> b1<105> b1<104> b1<103> b1<102> b1<101> b1<100> b1<99> b1<98> b1<97> b1<96> b1<95> b1<94> b1<93> b1<92> b1<91> b1<90> b1<89> b1<88> b1<87> b1<86> b1<85> b1<84> b1<83> b1<82> b1<81> b1<80> b1<79> b1<78> b1<77> b1<76> b1<75> b1<74> b1<73> b1<72> b1<71> b1<70> b1<69> b1<68> b1<67> b1<66> b1<65> b1<64> b1<63> b1<62> b1<61>
+b1<60> b1<59> b1<58> b1<57> b1<56> b1<55> b1<54> b1<53> b1<52> b1<51> b1<50> b1<49> b1<48> b1<47> b1<46> b1<45> b1<44> b1<43> b1<42> b1<41> b1<40> b1<39> b1<38> b1<37> b1<36> b1<35> b1<34> b1<33> b1<32> b1<31> b1<30> b1<29> b1<28> b1<27> b1<26> b1<25> b1<24> b1<23> b1<22> b1<21> b1<20> b1<19> b1<18> b1<17> b1<16> b1<15> b1<14> b1<13> b1<12> b1<11> b1<10> b1<9> b1<8> b1<7> b1<6> b1<5> b1<4> b1<3> b1<2> b1<1> b1<0> b<191> b<190> b<189> b<188> b<187> b<186> b<185> b<184> b<183> b<182> b<181> b<180> b<179> b<178> b<177> b<176> b<175> b<174> b<173> b<172> b<171> b<170> b<169> b<168> b<167> b<166> b<165> b<164> b<163> b<162> b<161> b<160> b<159> b<158> b<157> b<156> b<155> b<154> b<153> b<152> b<151> b<150> b<149> b<148> b<147> b<146> b<145> b<144> b<143> b<142> b<141> b<140> b<139> b<138> b<137> b<136> b<135> b<134> b<133> b<132> b<131> b<130> b<129> b<128> b<127> b<126> b<125> b<124> b<123> b<122> b<121> b<120> b<119> b<118> b<117> b<116> b<115> b<114> b<113> b<112> b<111> b<110> b<109> b<108> b<107> b<106>
+b<105> b<104> b<103> b<102> b<101> b<100> b<99> b<98> b<97> b<96> b<95> b<94> b<93> b<92> b<91> b<90> b<89> b<88> b<87> b<86> b<85> b<84> b<83> b<82> b<81> b<80> b<79> b<78> b<77> b<76> b<75> b<74> b<73> b<72> b<71> b<70> b<69> b<68> b<67> b<66> b<65> b<64> b<63> b<62> b<61> b<60> b<59> b<58> b<57> b<56> b<55> b<54> b<53> b<52> b<51> b<50> b<49> b<48> b<47> b<46> b<45> b<44> b<43> b<42> b<41> b<40> b<39> b<38> b<37> b<36> b<35> b<34> b<33> b<32> b<31> b<30> b<29> b<28> b<27> b<26> b<25> b<24> b<23> b<22> b<21> b<20> b<19> b<18> b<17> b<16> b<15> b<14> b<13> b<12> b<11> b<10> b<9> b<8> b<7> b<6> b<5> b<4> b<3> b<2> b<1> b<0> SRAM_192
xi17 wl<18> b1<191> b1<190> b1<189> b1<188> b1<187> b1<186> b1<185> b1<184> b1<183> b1<182> b1<181> b1<180> b1<179> b1<178> b1<177> b1<176> b1<175> b1<174> b1<173> b1<172> b1<171> b1<170> b1<169> b1<168> b1<167> b1<166> b1<165> b1<164> b1<163> b1<162> b1<161> b1<160> b1<159> b1<158> b1<157> b1<156> b1<155> b1<154> b1<153> b1<152> b1<151> b1<150> b1<149> b1<148> b1<147> b1<146> b1<145> b1<144> b1<143> b1<142> b1<141> b1<140> b1<139> b1<138> b1<137> b1<136> b1<135> b1<134> b1<133> b1<132> b1<131> b1<130> b1<129> b1<128> b1<127> b1<126> b1<125> b1<124> b1<123> b1<122> b1<121> b1<120> b1<119> b1<118> b1<117> b1<116> b1<115> b1<114> b1<113> b1<112> b1<111> b1<110> b1<109> b1<108> b1<107> b1<106> b1<105> b1<104> b1<103> b1<102> b1<101> b1<100> b1<99> b1<98> b1<97> b1<96> b1<95> b1<94> b1<93> b1<92> b1<91> b1<90> b1<89> b1<88> b1<87> b1<86> b1<85> b1<84> b1<83> b1<82> b1<81> b1<80> b1<79> b1<78> b1<77> b1<76> b1<75> b1<74> b1<73> b1<72> b1<71> b1<70> b1<69> b1<68> b1<67> b1<66> b1<65> b1<64> b1<63> b1<62> b1<61>
+b1<60> b1<59> b1<58> b1<57> b1<56> b1<55> b1<54> b1<53> b1<52> b1<51> b1<50> b1<49> b1<48> b1<47> b1<46> b1<45> b1<44> b1<43> b1<42> b1<41> b1<40> b1<39> b1<38> b1<37> b1<36> b1<35> b1<34> b1<33> b1<32> b1<31> b1<30> b1<29> b1<28> b1<27> b1<26> b1<25> b1<24> b1<23> b1<22> b1<21> b1<20> b1<19> b1<18> b1<17> b1<16> b1<15> b1<14> b1<13> b1<12> b1<11> b1<10> b1<9> b1<8> b1<7> b1<6> b1<5> b1<4> b1<3> b1<2> b1<1> b1<0> b<191> b<190> b<189> b<188> b<187> b<186> b<185> b<184> b<183> b<182> b<181> b<180> b<179> b<178> b<177> b<176> b<175> b<174> b<173> b<172> b<171> b<170> b<169> b<168> b<167> b<166> b<165> b<164> b<163> b<162> b<161> b<160> b<159> b<158> b<157> b<156> b<155> b<154> b<153> b<152> b<151> b<150> b<149> b<148> b<147> b<146> b<145> b<144> b<143> b<142> b<141> b<140> b<139> b<138> b<137> b<136> b<135> b<134> b<133> b<132> b<131> b<130> b<129> b<128> b<127> b<126> b<125> b<124> b<123> b<122> b<121> b<120> b<119> b<118> b<117> b<116> b<115> b<114> b<113> b<112> b<111> b<110> b<109> b<108> b<107> b<106>
+b<105> b<104> b<103> b<102> b<101> b<100> b<99> b<98> b<97> b<96> b<95> b<94> b<93> b<92> b<91> b<90> b<89> b<88> b<87> b<86> b<85> b<84> b<83> b<82> b<81> b<80> b<79> b<78> b<77> b<76> b<75> b<74> b<73> b<72> b<71> b<70> b<69> b<68> b<67> b<66> b<65> b<64> b<63> b<62> b<61> b<60> b<59> b<58> b<57> b<56> b<55> b<54> b<53> b<52> b<51> b<50> b<49> b<48> b<47> b<46> b<45> b<44> b<43> b<42> b<41> b<40> b<39> b<38> b<37> b<36> b<35> b<34> b<33> b<32> b<31> b<30> b<29> b<28> b<27> b<26> b<25> b<24> b<23> b<22> b<21> b<20> b<19> b<18> b<17> b<16> b<15> b<14> b<13> b<12> b<11> b<10> b<9> b<8> b<7> b<6> b<5> b<4> b<3> b<2> b<1> b<0> SRAM_192
xi16 wl<19> b1<191> b1<190> b1<189> b1<188> b1<187> b1<186> b1<185> b1<184> b1<183> b1<182> b1<181> b1<180> b1<179> b1<178> b1<177> b1<176> b1<175> b1<174> b1<173> b1<172> b1<171> b1<170> b1<169> b1<168> b1<167> b1<166> b1<165> b1<164> b1<163> b1<162> b1<161> b1<160> b1<159> b1<158> b1<157> b1<156> b1<155> b1<154> b1<153> b1<152> b1<151> b1<150> b1<149> b1<148> b1<147> b1<146> b1<145> b1<144> b1<143> b1<142> b1<141> b1<140> b1<139> b1<138> b1<137> b1<136> b1<135> b1<134> b1<133> b1<132> b1<131> b1<130> b1<129> b1<128> b1<127> b1<126> b1<125> b1<124> b1<123> b1<122> b1<121> b1<120> b1<119> b1<118> b1<117> b1<116> b1<115> b1<114> b1<113> b1<112> b1<111> b1<110> b1<109> b1<108> b1<107> b1<106> b1<105> b1<104> b1<103> b1<102> b1<101> b1<100> b1<99> b1<98> b1<97> b1<96> b1<95> b1<94> b1<93> b1<92> b1<91> b1<90> b1<89> b1<88> b1<87> b1<86> b1<85> b1<84> b1<83> b1<82> b1<81> b1<80> b1<79> b1<78> b1<77> b1<76> b1<75> b1<74> b1<73> b1<72> b1<71> b1<70> b1<69> b1<68> b1<67> b1<66> b1<65> b1<64> b1<63> b1<62> b1<61>
+b1<60> b1<59> b1<58> b1<57> b1<56> b1<55> b1<54> b1<53> b1<52> b1<51> b1<50> b1<49> b1<48> b1<47> b1<46> b1<45> b1<44> b1<43> b1<42> b1<41> b1<40> b1<39> b1<38> b1<37> b1<36> b1<35> b1<34> b1<33> b1<32> b1<31> b1<30> b1<29> b1<28> b1<27> b1<26> b1<25> b1<24> b1<23> b1<22> b1<21> b1<20> b1<19> b1<18> b1<17> b1<16> b1<15> b1<14> b1<13> b1<12> b1<11> b1<10> b1<9> b1<8> b1<7> b1<6> b1<5> b1<4> b1<3> b1<2> b1<1> b1<0> b<191> b<190> b<189> b<188> b<187> b<186> b<185> b<184> b<183> b<182> b<181> b<180> b<179> b<178> b<177> b<176> b<175> b<174> b<173> b<172> b<171> b<170> b<169> b<168> b<167> b<166> b<165> b<164> b<163> b<162> b<161> b<160> b<159> b<158> b<157> b<156> b<155> b<154> b<153> b<152> b<151> b<150> b<149> b<148> b<147> b<146> b<145> b<144> b<143> b<142> b<141> b<140> b<139> b<138> b<137> b<136> b<135> b<134> b<133> b<132> b<131> b<130> b<129> b<128> b<127> b<126> b<125> b<124> b<123> b<122> b<121> b<120> b<119> b<118> b<117> b<116> b<115> b<114> b<113> b<112> b<111> b<110> b<109> b<108> b<107> b<106>
+b<105> b<104> b<103> b<102> b<101> b<100> b<99> b<98> b<97> b<96> b<95> b<94> b<93> b<92> b<91> b<90> b<89> b<88> b<87> b<86> b<85> b<84> b<83> b<82> b<81> b<80> b<79> b<78> b<77> b<76> b<75> b<74> b<73> b<72> b<71> b<70> b<69> b<68> b<67> b<66> b<65> b<64> b<63> b<62> b<61> b<60> b<59> b<58> b<57> b<56> b<55> b<54> b<53> b<52> b<51> b<50> b<49> b<48> b<47> b<46> b<45> b<44> b<43> b<42> b<41> b<40> b<39> b<38> b<37> b<36> b<35> b<34> b<33> b<32> b<31> b<30> b<29> b<28> b<27> b<26> b<25> b<24> b<23> b<22> b<21> b<20> b<19> b<18> b<17> b<16> b<15> b<14> b<13> b<12> b<11> b<10> b<9> b<8> b<7> b<6> b<5> b<4> b<3> b<2> b<1> b<0> SRAM_192
xi15 wl<20> b1<191> b1<190> b1<189> b1<188> b1<187> b1<186> b1<185> b1<184> b1<183> b1<182> b1<181> b1<180> b1<179> b1<178> b1<177> b1<176> b1<175> b1<174> b1<173> b1<172> b1<171> b1<170> b1<169> b1<168> b1<167> b1<166> b1<165> b1<164> b1<163> b1<162> b1<161> b1<160> b1<159> b1<158> b1<157> b1<156> b1<155> b1<154> b1<153> b1<152> b1<151> b1<150> b1<149> b1<148> b1<147> b1<146> b1<145> b1<144> b1<143> b1<142> b1<141> b1<140> b1<139> b1<138> b1<137> b1<136> b1<135> b1<134> b1<133> b1<132> b1<131> b1<130> b1<129> b1<128> b1<127> b1<126> b1<125> b1<124> b1<123> b1<122> b1<121> b1<120> b1<119> b1<118> b1<117> b1<116> b1<115> b1<114> b1<113> b1<112> b1<111> b1<110> b1<109> b1<108> b1<107> b1<106> b1<105> b1<104> b1<103> b1<102> b1<101> b1<100> b1<99> b1<98> b1<97> b1<96> b1<95> b1<94> b1<93> b1<92> b1<91> b1<90> b1<89> b1<88> b1<87> b1<86> b1<85> b1<84> b1<83> b1<82> b1<81> b1<80> b1<79> b1<78> b1<77> b1<76> b1<75> b1<74> b1<73> b1<72> b1<71> b1<70> b1<69> b1<68> b1<67> b1<66> b1<65> b1<64> b1<63> b1<62> b1<61>
+b1<60> b1<59> b1<58> b1<57> b1<56> b1<55> b1<54> b1<53> b1<52> b1<51> b1<50> b1<49> b1<48> b1<47> b1<46> b1<45> b1<44> b1<43> b1<42> b1<41> b1<40> b1<39> b1<38> b1<37> b1<36> b1<35> b1<34> b1<33> b1<32> b1<31> b1<30> b1<29> b1<28> b1<27> b1<26> b1<25> b1<24> b1<23> b1<22> b1<21> b1<20> b1<19> b1<18> b1<17> b1<16> b1<15> b1<14> b1<13> b1<12> b1<11> b1<10> b1<9> b1<8> b1<7> b1<6> b1<5> b1<4> b1<3> b1<2> b1<1> b1<0> b<191> b<190> b<189> b<188> b<187> b<186> b<185> b<184> b<183> b<182> b<181> b<180> b<179> b<178> b<177> b<176> b<175> b<174> b<173> b<172> b<171> b<170> b<169> b<168> b<167> b<166> b<165> b<164> b<163> b<162> b<161> b<160> b<159> b<158> b<157> b<156> b<155> b<154> b<153> b<152> b<151> b<150> b<149> b<148> b<147> b<146> b<145> b<144> b<143> b<142> b<141> b<140> b<139> b<138> b<137> b<136> b<135> b<134> b<133> b<132> b<131> b<130> b<129> b<128> b<127> b<126> b<125> b<124> b<123> b<122> b<121> b<120> b<119> b<118> b<117> b<116> b<115> b<114> b<113> b<112> b<111> b<110> b<109> b<108> b<107> b<106>
+b<105> b<104> b<103> b<102> b<101> b<100> b<99> b<98> b<97> b<96> b<95> b<94> b<93> b<92> b<91> b<90> b<89> b<88> b<87> b<86> b<85> b<84> b<83> b<82> b<81> b<80> b<79> b<78> b<77> b<76> b<75> b<74> b<73> b<72> b<71> b<70> b<69> b<68> b<67> b<66> b<65> b<64> b<63> b<62> b<61> b<60> b<59> b<58> b<57> b<56> b<55> b<54> b<53> b<52> b<51> b<50> b<49> b<48> b<47> b<46> b<45> b<44> b<43> b<42> b<41> b<40> b<39> b<38> b<37> b<36> b<35> b<34> b<33> b<32> b<31> b<30> b<29> b<28> b<27> b<26> b<25> b<24> b<23> b<22> b<21> b<20> b<19> b<18> b<17> b<16> b<15> b<14> b<13> b<12> b<11> b<10> b<9> b<8> b<7> b<6> b<5> b<4> b<3> b<2> b<1> b<0> SRAM_192
xi14 wl<21> b1<191> b1<190> b1<189> b1<188> b1<187> b1<186> b1<185> b1<184> b1<183> b1<182> b1<181> b1<180> b1<179> b1<178> b1<177> b1<176> b1<175> b1<174> b1<173> b1<172> b1<171> b1<170> b1<169> b1<168> b1<167> b1<166> b1<165> b1<164> b1<163> b1<162> b1<161> b1<160> b1<159> b1<158> b1<157> b1<156> b1<155> b1<154> b1<153> b1<152> b1<151> b1<150> b1<149> b1<148> b1<147> b1<146> b1<145> b1<144> b1<143> b1<142> b1<141> b1<140> b1<139> b1<138> b1<137> b1<136> b1<135> b1<134> b1<133> b1<132> b1<131> b1<130> b1<129> b1<128> b1<127> b1<126> b1<125> b1<124> b1<123> b1<122> b1<121> b1<120> b1<119> b1<118> b1<117> b1<116> b1<115> b1<114> b1<113> b1<112> b1<111> b1<110> b1<109> b1<108> b1<107> b1<106> b1<105> b1<104> b1<103> b1<102> b1<101> b1<100> b1<99> b1<98> b1<97> b1<96> b1<95> b1<94> b1<93> b1<92> b1<91> b1<90> b1<89> b1<88> b1<87> b1<86> b1<85> b1<84> b1<83> b1<82> b1<81> b1<80> b1<79> b1<78> b1<77> b1<76> b1<75> b1<74> b1<73> b1<72> b1<71> b1<70> b1<69> b1<68> b1<67> b1<66> b1<65> b1<64> b1<63> b1<62> b1<61>
+b1<60> b1<59> b1<58> b1<57> b1<56> b1<55> b1<54> b1<53> b1<52> b1<51> b1<50> b1<49> b1<48> b1<47> b1<46> b1<45> b1<44> b1<43> b1<42> b1<41> b1<40> b1<39> b1<38> b1<37> b1<36> b1<35> b1<34> b1<33> b1<32> b1<31> b1<30> b1<29> b1<28> b1<27> b1<26> b1<25> b1<24> b1<23> b1<22> b1<21> b1<20> b1<19> b1<18> b1<17> b1<16> b1<15> b1<14> b1<13> b1<12> b1<11> b1<10> b1<9> b1<8> b1<7> b1<6> b1<5> b1<4> b1<3> b1<2> b1<1> b1<0> b<191> b<190> b<189> b<188> b<187> b<186> b<185> b<184> b<183> b<182> b<181> b<180> b<179> b<178> b<177> b<176> b<175> b<174> b<173> b<172> b<171> b<170> b<169> b<168> b<167> b<166> b<165> b<164> b<163> b<162> b<161> b<160> b<159> b<158> b<157> b<156> b<155> b<154> b<153> b<152> b<151> b<150> b<149> b<148> b<147> b<146> b<145> b<144> b<143> b<142> b<141> b<140> b<139> b<138> b<137> b<136> b<135> b<134> b<133> b<132> b<131> b<130> b<129> b<128> b<127> b<126> b<125> b<124> b<123> b<122> b<121> b<120> b<119> b<118> b<117> b<116> b<115> b<114> b<113> b<112> b<111> b<110> b<109> b<108> b<107> b<106>
+b<105> b<104> b<103> b<102> b<101> b<100> b<99> b<98> b<97> b<96> b<95> b<94> b<93> b<92> b<91> b<90> b<89> b<88> b<87> b<86> b<85> b<84> b<83> b<82> b<81> b<80> b<79> b<78> b<77> b<76> b<75> b<74> b<73> b<72> b<71> b<70> b<69> b<68> b<67> b<66> b<65> b<64> b<63> b<62> b<61> b<60> b<59> b<58> b<57> b<56> b<55> b<54> b<53> b<52> b<51> b<50> b<49> b<48> b<47> b<46> b<45> b<44> b<43> b<42> b<41> b<40> b<39> b<38> b<37> b<36> b<35> b<34> b<33> b<32> b<31> b<30> b<29> b<28> b<27> b<26> b<25> b<24> b<23> b<22> b<21> b<20> b<19> b<18> b<17> b<16> b<15> b<14> b<13> b<12> b<11> b<10> b<9> b<8> b<7> b<6> b<5> b<4> b<3> b<2> b<1> b<0> SRAM_192
xi13 wl<22> b1<191> b1<190> b1<189> b1<188> b1<187> b1<186> b1<185> b1<184> b1<183> b1<182> b1<181> b1<180> b1<179> b1<178> b1<177> b1<176> b1<175> b1<174> b1<173> b1<172> b1<171> b1<170> b1<169> b1<168> b1<167> b1<166> b1<165> b1<164> b1<163> b1<162> b1<161> b1<160> b1<159> b1<158> b1<157> b1<156> b1<155> b1<154> b1<153> b1<152> b1<151> b1<150> b1<149> b1<148> b1<147> b1<146> b1<145> b1<144> b1<143> b1<142> b1<141> b1<140> b1<139> b1<138> b1<137> b1<136> b1<135> b1<134> b1<133> b1<132> b1<131> b1<130> b1<129> b1<128> b1<127> b1<126> b1<125> b1<124> b1<123> b1<122> b1<121> b1<120> b1<119> b1<118> b1<117> b1<116> b1<115> b1<114> b1<113> b1<112> b1<111> b1<110> b1<109> b1<108> b1<107> b1<106> b1<105> b1<104> b1<103> b1<102> b1<101> b1<100> b1<99> b1<98> b1<97> b1<96> b1<95> b1<94> b1<93> b1<92> b1<91> b1<90> b1<89> b1<88> b1<87> b1<86> b1<85> b1<84> b1<83> b1<82> b1<81> b1<80> b1<79> b1<78> b1<77> b1<76> b1<75> b1<74> b1<73> b1<72> b1<71> b1<70> b1<69> b1<68> b1<67> b1<66> b1<65> b1<64> b1<63> b1<62> b1<61>
+b1<60> b1<59> b1<58> b1<57> b1<56> b1<55> b1<54> b1<53> b1<52> b1<51> b1<50> b1<49> b1<48> b1<47> b1<46> b1<45> b1<44> b1<43> b1<42> b1<41> b1<40> b1<39> b1<38> b1<37> b1<36> b1<35> b1<34> b1<33> b1<32> b1<31> b1<30> b1<29> b1<28> b1<27> b1<26> b1<25> b1<24> b1<23> b1<22> b1<21> b1<20> b1<19> b1<18> b1<17> b1<16> b1<15> b1<14> b1<13> b1<12> b1<11> b1<10> b1<9> b1<8> b1<7> b1<6> b1<5> b1<4> b1<3> b1<2> b1<1> b1<0> b<191> b<190> b<189> b<188> b<187> b<186> b<185> b<184> b<183> b<182> b<181> b<180> b<179> b<178> b<177> b<176> b<175> b<174> b<173> b<172> b<171> b<170> b<169> b<168> b<167> b<166> b<165> b<164> b<163> b<162> b<161> b<160> b<159> b<158> b<157> b<156> b<155> b<154> b<153> b<152> b<151> b<150> b<149> b<148> b<147> b<146> b<145> b<144> b<143> b<142> b<141> b<140> b<139> b<138> b<137> b<136> b<135> b<134> b<133> b<132> b<131> b<130> b<129> b<128> b<127> b<126> b<125> b<124> b<123> b<122> b<121> b<120> b<119> b<118> b<117> b<116> b<115> b<114> b<113> b<112> b<111> b<110> b<109> b<108> b<107> b<106>
+b<105> b<104> b<103> b<102> b<101> b<100> b<99> b<98> b<97> b<96> b<95> b<94> b<93> b<92> b<91> b<90> b<89> b<88> b<87> b<86> b<85> b<84> b<83> b<82> b<81> b<80> b<79> b<78> b<77> b<76> b<75> b<74> b<73> b<72> b<71> b<70> b<69> b<68> b<67> b<66> b<65> b<64> b<63> b<62> b<61> b<60> b<59> b<58> b<57> b<56> b<55> b<54> b<53> b<52> b<51> b<50> b<49> b<48> b<47> b<46> b<45> b<44> b<43> b<42> b<41> b<40> b<39> b<38> b<37> b<36> b<35> b<34> b<33> b<32> b<31> b<30> b<29> b<28> b<27> b<26> b<25> b<24> b<23> b<22> b<21> b<20> b<19> b<18> b<17> b<16> b<15> b<14> b<13> b<12> b<11> b<10> b<9> b<8> b<7> b<6> b<5> b<4> b<3> b<2> b<1> b<0> SRAM_192
xi12 wl<23> b1<191> b1<190> b1<189> b1<188> b1<187> b1<186> b1<185> b1<184> b1<183> b1<182> b1<181> b1<180> b1<179> b1<178> b1<177> b1<176> b1<175> b1<174> b1<173> b1<172> b1<171> b1<170> b1<169> b1<168> b1<167> b1<166> b1<165> b1<164> b1<163> b1<162> b1<161> b1<160> b1<159> b1<158> b1<157> b1<156> b1<155> b1<154> b1<153> b1<152> b1<151> b1<150> b1<149> b1<148> b1<147> b1<146> b1<145> b1<144> b1<143> b1<142> b1<141> b1<140> b1<139> b1<138> b1<137> b1<136> b1<135> b1<134> b1<133> b1<132> b1<131> b1<130> b1<129> b1<128> b1<127> b1<126> b1<125> b1<124> b1<123> b1<122> b1<121> b1<120> b1<119> b1<118> b1<117> b1<116> b1<115> b1<114> b1<113> b1<112> b1<111> b1<110> b1<109> b1<108> b1<107> b1<106> b1<105> b1<104> b1<103> b1<102> b1<101> b1<100> b1<99> b1<98> b1<97> b1<96> b1<95> b1<94> b1<93> b1<92> b1<91> b1<90> b1<89> b1<88> b1<87> b1<86> b1<85> b1<84> b1<83> b1<82> b1<81> b1<80> b1<79> b1<78> b1<77> b1<76> b1<75> b1<74> b1<73> b1<72> b1<71> b1<70> b1<69> b1<68> b1<67> b1<66> b1<65> b1<64> b1<63> b1<62> b1<61>
+b1<60> b1<59> b1<58> b1<57> b1<56> b1<55> b1<54> b1<53> b1<52> b1<51> b1<50> b1<49> b1<48> b1<47> b1<46> b1<45> b1<44> b1<43> b1<42> b1<41> b1<40> b1<39> b1<38> b1<37> b1<36> b1<35> b1<34> b1<33> b1<32> b1<31> b1<30> b1<29> b1<28> b1<27> b1<26> b1<25> b1<24> b1<23> b1<22> b1<21> b1<20> b1<19> b1<18> b1<17> b1<16> b1<15> b1<14> b1<13> b1<12> b1<11> b1<10> b1<9> b1<8> b1<7> b1<6> b1<5> b1<4> b1<3> b1<2> b1<1> b1<0> b<191> b<190> b<189> b<188> b<187> b<186> b<185> b<184> b<183> b<182> b<181> b<180> b<179> b<178> b<177> b<176> b<175> b<174> b<173> b<172> b<171> b<170> b<169> b<168> b<167> b<166> b<165> b<164> b<163> b<162> b<161> b<160> b<159> b<158> b<157> b<156> b<155> b<154> b<153> b<152> b<151> b<150> b<149> b<148> b<147> b<146> b<145> b<144> b<143> b<142> b<141> b<140> b<139> b<138> b<137> b<136> b<135> b<134> b<133> b<132> b<131> b<130> b<129> b<128> b<127> b<126> b<125> b<124> b<123> b<122> b<121> b<120> b<119> b<118> b<117> b<116> b<115> b<114> b<113> b<112> b<111> b<110> b<109> b<108> b<107> b<106>
+b<105> b<104> b<103> b<102> b<101> b<100> b<99> b<98> b<97> b<96> b<95> b<94> b<93> b<92> b<91> b<90> b<89> b<88> b<87> b<86> b<85> b<84> b<83> b<82> b<81> b<80> b<79> b<78> b<77> b<76> b<75> b<74> b<73> b<72> b<71> b<70> b<69> b<68> b<67> b<66> b<65> b<64> b<63> b<62> b<61> b<60> b<59> b<58> b<57> b<56> b<55> b<54> b<53> b<52> b<51> b<50> b<49> b<48> b<47> b<46> b<45> b<44> b<43> b<42> b<41> b<40> b<39> b<38> b<37> b<36> b<35> b<34> b<33> b<32> b<31> b<30> b<29> b<28> b<27> b<26> b<25> b<24> b<23> b<22> b<21> b<20> b<19> b<18> b<17> b<16> b<15> b<14> b<13> b<12> b<11> b<10> b<9> b<8> b<7> b<6> b<5> b<4> b<3> b<2> b<1> b<0> SRAM_192
xi11 wl<24> b1<191> b1<190> b1<189> b1<188> b1<187> b1<186> b1<185> b1<184> b1<183> b1<182> b1<181> b1<180> b1<179> b1<178> b1<177> b1<176> b1<175> b1<174> b1<173> b1<172> b1<171> b1<170> b1<169> b1<168> b1<167> b1<166> b1<165> b1<164> b1<163> b1<162> b1<161> b1<160> b1<159> b1<158> b1<157> b1<156> b1<155> b1<154> b1<153> b1<152> b1<151> b1<150> b1<149> b1<148> b1<147> b1<146> b1<145> b1<144> b1<143> b1<142> b1<141> b1<140> b1<139> b1<138> b1<137> b1<136> b1<135> b1<134> b1<133> b1<132> b1<131> b1<130> b1<129> b1<128> b1<127> b1<126> b1<125> b1<124> b1<123> b1<122> b1<121> b1<120> b1<119> b1<118> b1<117> b1<116> b1<115> b1<114> b1<113> b1<112> b1<111> b1<110> b1<109> b1<108> b1<107> b1<106> b1<105> b1<104> b1<103> b1<102> b1<101> b1<100> b1<99> b1<98> b1<97> b1<96> b1<95> b1<94> b1<93> b1<92> b1<91> b1<90> b1<89> b1<88> b1<87> b1<86> b1<85> b1<84> b1<83> b1<82> b1<81> b1<80> b1<79> b1<78> b1<77> b1<76> b1<75> b1<74> b1<73> b1<72> b1<71> b1<70> b1<69> b1<68> b1<67> b1<66> b1<65> b1<64> b1<63> b1<62> b1<61>
+b1<60> b1<59> b1<58> b1<57> b1<56> b1<55> b1<54> b1<53> b1<52> b1<51> b1<50> b1<49> b1<48> b1<47> b1<46> b1<45> b1<44> b1<43> b1<42> b1<41> b1<40> b1<39> b1<38> b1<37> b1<36> b1<35> b1<34> b1<33> b1<32> b1<31> b1<30> b1<29> b1<28> b1<27> b1<26> b1<25> b1<24> b1<23> b1<22> b1<21> b1<20> b1<19> b1<18> b1<17> b1<16> b1<15> b1<14> b1<13> b1<12> b1<11> b1<10> b1<9> b1<8> b1<7> b1<6> b1<5> b1<4> b1<3> b1<2> b1<1> b1<0> b<191> b<190> b<189> b<188> b<187> b<186> b<185> b<184> b<183> b<182> b<181> b<180> b<179> b<178> b<177> b<176> b<175> b<174> b<173> b<172> b<171> b<170> b<169> b<168> b<167> b<166> b<165> b<164> b<163> b<162> b<161> b<160> b<159> b<158> b<157> b<156> b<155> b<154> b<153> b<152> b<151> b<150> b<149> b<148> b<147> b<146> b<145> b<144> b<143> b<142> b<141> b<140> b<139> b<138> b<137> b<136> b<135> b<134> b<133> b<132> b<131> b<130> b<129> b<128> b<127> b<126> b<125> b<124> b<123> b<122> b<121> b<120> b<119> b<118> b<117> b<116> b<115> b<114> b<113> b<112> b<111> b<110> b<109> b<108> b<107> b<106>
+b<105> b<104> b<103> b<102> b<101> b<100> b<99> b<98> b<97> b<96> b<95> b<94> b<93> b<92> b<91> b<90> b<89> b<88> b<87> b<86> b<85> b<84> b<83> b<82> b<81> b<80> b<79> b<78> b<77> b<76> b<75> b<74> b<73> b<72> b<71> b<70> b<69> b<68> b<67> b<66> b<65> b<64> b<63> b<62> b<61> b<60> b<59> b<58> b<57> b<56> b<55> b<54> b<53> b<52> b<51> b<50> b<49> b<48> b<47> b<46> b<45> b<44> b<43> b<42> b<41> b<40> b<39> b<38> b<37> b<36> b<35> b<34> b<33> b<32> b<31> b<30> b<29> b<28> b<27> b<26> b<25> b<24> b<23> b<22> b<21> b<20> b<19> b<18> b<17> b<16> b<15> b<14> b<13> b<12> b<11> b<10> b<9> b<8> b<7> b<6> b<5> b<4> b<3> b<2> b<1> b<0> SRAM_192
xi10 wl<25> b1<191> b1<190> b1<189> b1<188> b1<187> b1<186> b1<185> b1<184> b1<183> b1<182> b1<181> b1<180> b1<179> b1<178> b1<177> b1<176> b1<175> b1<174> b1<173> b1<172> b1<171> b1<170> b1<169> b1<168> b1<167> b1<166> b1<165> b1<164> b1<163> b1<162> b1<161> b1<160> b1<159> b1<158> b1<157> b1<156> b1<155> b1<154> b1<153> b1<152> b1<151> b1<150> b1<149> b1<148> b1<147> b1<146> b1<145> b1<144> b1<143> b1<142> b1<141> b1<140> b1<139> b1<138> b1<137> b1<136> b1<135> b1<134> b1<133> b1<132> b1<131> b1<130> b1<129> b1<128> b1<127> b1<126> b1<125> b1<124> b1<123> b1<122> b1<121> b1<120> b1<119> b1<118> b1<117> b1<116> b1<115> b1<114> b1<113> b1<112> b1<111> b1<110> b1<109> b1<108> b1<107> b1<106> b1<105> b1<104> b1<103> b1<102> b1<101> b1<100> b1<99> b1<98> b1<97> b1<96> b1<95> b1<94> b1<93> b1<92> b1<91> b1<90> b1<89> b1<88> b1<87> b1<86> b1<85> b1<84> b1<83> b1<82> b1<81> b1<80> b1<79> b1<78> b1<77> b1<76> b1<75> b1<74> b1<73> b1<72> b1<71> b1<70> b1<69> b1<68> b1<67> b1<66> b1<65> b1<64> b1<63> b1<62> b1<61>
+b1<60> b1<59> b1<58> b1<57> b1<56> b1<55> b1<54> b1<53> b1<52> b1<51> b1<50> b1<49> b1<48> b1<47> b1<46> b1<45> b1<44> b1<43> b1<42> b1<41> b1<40> b1<39> b1<38> b1<37> b1<36> b1<35> b1<34> b1<33> b1<32> b1<31> b1<30> b1<29> b1<28> b1<27> b1<26> b1<25> b1<24> b1<23> b1<22> b1<21> b1<20> b1<19> b1<18> b1<17> b1<16> b1<15> b1<14> b1<13> b1<12> b1<11> b1<10> b1<9> b1<8> b1<7> b1<6> b1<5> b1<4> b1<3> b1<2> b1<1> b1<0> b<191> b<190> b<189> b<188> b<187> b<186> b<185> b<184> b<183> b<182> b<181> b<180> b<179> b<178> b<177> b<176> b<175> b<174> b<173> b<172> b<171> b<170> b<169> b<168> b<167> b<166> b<165> b<164> b<163> b<162> b<161> b<160> b<159> b<158> b<157> b<156> b<155> b<154> b<153> b<152> b<151> b<150> b<149> b<148> b<147> b<146> b<145> b<144> b<143> b<142> b<141> b<140> b<139> b<138> b<137> b<136> b<135> b<134> b<133> b<132> b<131> b<130> b<129> b<128> b<127> b<126> b<125> b<124> b<123> b<122> b<121> b<120> b<119> b<118> b<117> b<116> b<115> b<114> b<113> b<112> b<111> b<110> b<109> b<108> b<107> b<106>
+b<105> b<104> b<103> b<102> b<101> b<100> b<99> b<98> b<97> b<96> b<95> b<94> b<93> b<92> b<91> b<90> b<89> b<88> b<87> b<86> b<85> b<84> b<83> b<82> b<81> b<80> b<79> b<78> b<77> b<76> b<75> b<74> b<73> b<72> b<71> b<70> b<69> b<68> b<67> b<66> b<65> b<64> b<63> b<62> b<61> b<60> b<59> b<58> b<57> b<56> b<55> b<54> b<53> b<52> b<51> b<50> b<49> b<48> b<47> b<46> b<45> b<44> b<43> b<42> b<41> b<40> b<39> b<38> b<37> b<36> b<35> b<34> b<33> b<32> b<31> b<30> b<29> b<28> b<27> b<26> b<25> b<24> b<23> b<22> b<21> b<20> b<19> b<18> b<17> b<16> b<15> b<14> b<13> b<12> b<11> b<10> b<9> b<8> b<7> b<6> b<5> b<4> b<3> b<2> b<1> b<0> SRAM_192
xi9 wl<26> b1<191> b1<190> b1<189> b1<188> b1<187> b1<186> b1<185> b1<184> b1<183> b1<182> b1<181> b1<180> b1<179> b1<178> b1<177> b1<176> b1<175> b1<174> b1<173> b1<172> b1<171> b1<170> b1<169> b1<168> b1<167> b1<166> b1<165> b1<164> b1<163> b1<162> b1<161> b1<160> b1<159> b1<158> b1<157> b1<156> b1<155> b1<154> b1<153> b1<152> b1<151> b1<150> b1<149> b1<148> b1<147> b1<146> b1<145> b1<144> b1<143> b1<142> b1<141> b1<140> b1<139> b1<138> b1<137> b1<136> b1<135> b1<134> b1<133> b1<132> b1<131> b1<130> b1<129> b1<128> b1<127> b1<126> b1<125> b1<124> b1<123> b1<122> b1<121> b1<120> b1<119> b1<118> b1<117> b1<116> b1<115> b1<114> b1<113> b1<112> b1<111> b1<110> b1<109> b1<108> b1<107> b1<106> b1<105> b1<104> b1<103> b1<102> b1<101> b1<100> b1<99> b1<98> b1<97> b1<96> b1<95> b1<94> b1<93> b1<92> b1<91> b1<90> b1<89> b1<88> b1<87> b1<86> b1<85> b1<84> b1<83> b1<82> b1<81> b1<80> b1<79> b1<78> b1<77> b1<76> b1<75> b1<74> b1<73> b1<72> b1<71> b1<70> b1<69> b1<68> b1<67> b1<66> b1<65> b1<64> b1<63> b1<62> b1<61>
+b1<60> b1<59> b1<58> b1<57> b1<56> b1<55> b1<54> b1<53> b1<52> b1<51> b1<50> b1<49> b1<48> b1<47> b1<46> b1<45> b1<44> b1<43> b1<42> b1<41> b1<40> b1<39> b1<38> b1<37> b1<36> b1<35> b1<34> b1<33> b1<32> b1<31> b1<30> b1<29> b1<28> b1<27> b1<26> b1<25> b1<24> b1<23> b1<22> b1<21> b1<20> b1<19> b1<18> b1<17> b1<16> b1<15> b1<14> b1<13> b1<12> b1<11> b1<10> b1<9> b1<8> b1<7> b1<6> b1<5> b1<4> b1<3> b1<2> b1<1> b1<0> b<191> b<190> b<189> b<188> b<187> b<186> b<185> b<184> b<183> b<182> b<181> b<180> b<179> b<178> b<177> b<176> b<175> b<174> b<173> b<172> b<171> b<170> b<169> b<168> b<167> b<166> b<165> b<164> b<163> b<162> b<161> b<160> b<159> b<158> b<157> b<156> b<155> b<154> b<153> b<152> b<151> b<150> b<149> b<148> b<147> b<146> b<145> b<144> b<143> b<142> b<141> b<140> b<139> b<138> b<137> b<136> b<135> b<134> b<133> b<132> b<131> b<130> b<129> b<128> b<127> b<126> b<125> b<124> b<123> b<122> b<121> b<120> b<119> b<118> b<117> b<116> b<115> b<114> b<113> b<112> b<111> b<110> b<109> b<108> b<107> b<106>
+b<105> b<104> b<103> b<102> b<101> b<100> b<99> b<98> b<97> b<96> b<95> b<94> b<93> b<92> b<91> b<90> b<89> b<88> b<87> b<86> b<85> b<84> b<83> b<82> b<81> b<80> b<79> b<78> b<77> b<76> b<75> b<74> b<73> b<72> b<71> b<70> b<69> b<68> b<67> b<66> b<65> b<64> b<63> b<62> b<61> b<60> b<59> b<58> b<57> b<56> b<55> b<54> b<53> b<52> b<51> b<50> b<49> b<48> b<47> b<46> b<45> b<44> b<43> b<42> b<41> b<40> b<39> b<38> b<37> b<36> b<35> b<34> b<33> b<32> b<31> b<30> b<29> b<28> b<27> b<26> b<25> b<24> b<23> b<22> b<21> b<20> b<19> b<18> b<17> b<16> b<15> b<14> b<13> b<12> b<11> b<10> b<9> b<8> b<7> b<6> b<5> b<4> b<3> b<2> b<1> b<0> SRAM_192
xi8 wl<27> b1<191> b1<190> b1<189> b1<188> b1<187> b1<186> b1<185> b1<184> b1<183> b1<182> b1<181> b1<180> b1<179> b1<178> b1<177> b1<176> b1<175> b1<174> b1<173> b1<172> b1<171> b1<170> b1<169> b1<168> b1<167> b1<166> b1<165> b1<164> b1<163> b1<162> b1<161> b1<160> b1<159> b1<158> b1<157> b1<156> b1<155> b1<154> b1<153> b1<152> b1<151> b1<150> b1<149> b1<148> b1<147> b1<146> b1<145> b1<144> b1<143> b1<142> b1<141> b1<140> b1<139> b1<138> b1<137> b1<136> b1<135> b1<134> b1<133> b1<132> b1<131> b1<130> b1<129> b1<128> b1<127> b1<126> b1<125> b1<124> b1<123> b1<122> b1<121> b1<120> b1<119> b1<118> b1<117> b1<116> b1<115> b1<114> b1<113> b1<112> b1<111> b1<110> b1<109> b1<108> b1<107> b1<106> b1<105> b1<104> b1<103> b1<102> b1<101> b1<100> b1<99> b1<98> b1<97> b1<96> b1<95> b1<94> b1<93> b1<92> b1<91> b1<90> b1<89> b1<88> b1<87> b1<86> b1<85> b1<84> b1<83> b1<82> b1<81> b1<80> b1<79> b1<78> b1<77> b1<76> b1<75> b1<74> b1<73> b1<72> b1<71> b1<70> b1<69> b1<68> b1<67> b1<66> b1<65> b1<64> b1<63> b1<62> b1<61>
+b1<60> b1<59> b1<58> b1<57> b1<56> b1<55> b1<54> b1<53> b1<52> b1<51> b1<50> b1<49> b1<48> b1<47> b1<46> b1<45> b1<44> b1<43> b1<42> b1<41> b1<40> b1<39> b1<38> b1<37> b1<36> b1<35> b1<34> b1<33> b1<32> b1<31> b1<30> b1<29> b1<28> b1<27> b1<26> b1<25> b1<24> b1<23> b1<22> b1<21> b1<20> b1<19> b1<18> b1<17> b1<16> b1<15> b1<14> b1<13> b1<12> b1<11> b1<10> b1<9> b1<8> b1<7> b1<6> b1<5> b1<4> b1<3> b1<2> b1<1> b1<0> b<191> b<190> b<189> b<188> b<187> b<186> b<185> b<184> b<183> b<182> b<181> b<180> b<179> b<178> b<177> b<176> b<175> b<174> b<173> b<172> b<171> b<170> b<169> b<168> b<167> b<166> b<165> b<164> b<163> b<162> b<161> b<160> b<159> b<158> b<157> b<156> b<155> b<154> b<153> b<152> b<151> b<150> b<149> b<148> b<147> b<146> b<145> b<144> b<143> b<142> b<141> b<140> b<139> b<138> b<137> b<136> b<135> b<134> b<133> b<132> b<131> b<130> b<129> b<128> b<127> b<126> b<125> b<124> b<123> b<122> b<121> b<120> b<119> b<118> b<117> b<116> b<115> b<114> b<113> b<112> b<111> b<110> b<109> b<108> b<107> b<106>
+b<105> b<104> b<103> b<102> b<101> b<100> b<99> b<98> b<97> b<96> b<95> b<94> b<93> b<92> b<91> b<90> b<89> b<88> b<87> b<86> b<85> b<84> b<83> b<82> b<81> b<80> b<79> b<78> b<77> b<76> b<75> b<74> b<73> b<72> b<71> b<70> b<69> b<68> b<67> b<66> b<65> b<64> b<63> b<62> b<61> b<60> b<59> b<58> b<57> b<56> b<55> b<54> b<53> b<52> b<51> b<50> b<49> b<48> b<47> b<46> b<45> b<44> b<43> b<42> b<41> b<40> b<39> b<38> b<37> b<36> b<35> b<34> b<33> b<32> b<31> b<30> b<29> b<28> b<27> b<26> b<25> b<24> b<23> b<22> b<21> b<20> b<19> b<18> b<17> b<16> b<15> b<14> b<13> b<12> b<11> b<10> b<9> b<8> b<7> b<6> b<5> b<4> b<3> b<2> b<1> b<0> SRAM_192
xi7 wl<28> b1<191> b1<190> b1<189> b1<188> b1<187> b1<186> b1<185> b1<184> b1<183> b1<182> b1<181> b1<180> b1<179> b1<178> b1<177> b1<176> b1<175> b1<174> b1<173> b1<172> b1<171> b1<170> b1<169> b1<168> b1<167> b1<166> b1<165> b1<164> b1<163> b1<162> b1<161> b1<160> b1<159> b1<158> b1<157> b1<156> b1<155> b1<154> b1<153> b1<152> b1<151> b1<150> b1<149> b1<148> b1<147> b1<146> b1<145> b1<144> b1<143> b1<142> b1<141> b1<140> b1<139> b1<138> b1<137> b1<136> b1<135> b1<134> b1<133> b1<132> b1<131> b1<130> b1<129> b1<128> b1<127> b1<126> b1<125> b1<124> b1<123> b1<122> b1<121> b1<120> b1<119> b1<118> b1<117> b1<116> b1<115> b1<114> b1<113> b1<112> b1<111> b1<110> b1<109> b1<108> b1<107> b1<106> b1<105> b1<104> b1<103> b1<102> b1<101> b1<100> b1<99> b1<98> b1<97> b1<96> b1<95> b1<94> b1<93> b1<92> b1<91> b1<90> b1<89> b1<88> b1<87> b1<86> b1<85> b1<84> b1<83> b1<82> b1<81> b1<80> b1<79> b1<78> b1<77> b1<76> b1<75> b1<74> b1<73> b1<72> b1<71> b1<70> b1<69> b1<68> b1<67> b1<66> b1<65> b1<64> b1<63> b1<62> b1<61>
+b1<60> b1<59> b1<58> b1<57> b1<56> b1<55> b1<54> b1<53> b1<52> b1<51> b1<50> b1<49> b1<48> b1<47> b1<46> b1<45> b1<44> b1<43> b1<42> b1<41> b1<40> b1<39> b1<38> b1<37> b1<36> b1<35> b1<34> b1<33> b1<32> b1<31> b1<30> b1<29> b1<28> b1<27> b1<26> b1<25> b1<24> b1<23> b1<22> b1<21> b1<20> b1<19> b1<18> b1<17> b1<16> b1<15> b1<14> b1<13> b1<12> b1<11> b1<10> b1<9> b1<8> b1<7> b1<6> b1<5> b1<4> b1<3> b1<2> b1<1> b1<0> b<191> b<190> b<189> b<188> b<187> b<186> b<185> b<184> b<183> b<182> b<181> b<180> b<179> b<178> b<177> b<176> b<175> b<174> b<173> b<172> b<171> b<170> b<169> b<168> b<167> b<166> b<165> b<164> b<163> b<162> b<161> b<160> b<159> b<158> b<157> b<156> b<155> b<154> b<153> b<152> b<151> b<150> b<149> b<148> b<147> b<146> b<145> b<144> b<143> b<142> b<141> b<140> b<139> b<138> b<137> b<136> b<135> b<134> b<133> b<132> b<131> b<130> b<129> b<128> b<127> b<126> b<125> b<124> b<123> b<122> b<121> b<120> b<119> b<118> b<117> b<116> b<115> b<114> b<113> b<112> b<111> b<110> b<109> b<108> b<107> b<106>
+b<105> b<104> b<103> b<102> b<101> b<100> b<99> b<98> b<97> b<96> b<95> b<94> b<93> b<92> b<91> b<90> b<89> b<88> b<87> b<86> b<85> b<84> b<83> b<82> b<81> b<80> b<79> b<78> b<77> b<76> b<75> b<74> b<73> b<72> b<71> b<70> b<69> b<68> b<67> b<66> b<65> b<64> b<63> b<62> b<61> b<60> b<59> b<58> b<57> b<56> b<55> b<54> b<53> b<52> b<51> b<50> b<49> b<48> b<47> b<46> b<45> b<44> b<43> b<42> b<41> b<40> b<39> b<38> b<37> b<36> b<35> b<34> b<33> b<32> b<31> b<30> b<29> b<28> b<27> b<26> b<25> b<24> b<23> b<22> b<21> b<20> b<19> b<18> b<17> b<16> b<15> b<14> b<13> b<12> b<11> b<10> b<9> b<8> b<7> b<6> b<5> b<4> b<3> b<2> b<1> b<0> SRAM_192
xi5 wl<30> b1<191> b1<190> b1<189> b1<188> b1<187> b1<186> b1<185> b1<184> b1<183> b1<182> b1<181> b1<180> b1<179> b1<178> b1<177> b1<176> b1<175> b1<174> b1<173> b1<172> b1<171> b1<170> b1<169> b1<168> b1<167> b1<166> b1<165> b1<164> b1<163> b1<162> b1<161> b1<160> b1<159> b1<158> b1<157> b1<156> b1<155> b1<154> b1<153> b1<152> b1<151> b1<150> b1<149> b1<148> b1<147> b1<146> b1<145> b1<144> b1<143> b1<142> b1<141> b1<140> b1<139> b1<138> b1<137> b1<136> b1<135> b1<134> b1<133> b1<132> b1<131> b1<130> b1<129> b1<128> b1<127> b1<126> b1<125> b1<124> b1<123> b1<122> b1<121> b1<120> b1<119> b1<118> b1<117> b1<116> b1<115> b1<114> b1<113> b1<112> b1<111> b1<110> b1<109> b1<108> b1<107> b1<106> b1<105> b1<104> b1<103> b1<102> b1<101> b1<100> b1<99> b1<98> b1<97> b1<96> b1<95> b1<94> b1<93> b1<92> b1<91> b1<90> b1<89> b1<88> b1<87> b1<86> b1<85> b1<84> b1<83> b1<82> b1<81> b1<80> b1<79> b1<78> b1<77> b1<76> b1<75> b1<74> b1<73> b1<72> b1<71> b1<70> b1<69> b1<68> b1<67> b1<66> b1<65> b1<64> b1<63> b1<62> b1<61>
+b1<60> b1<59> b1<58> b1<57> b1<56> b1<55> b1<54> b1<53> b1<52> b1<51> b1<50> b1<49> b1<48> b1<47> b1<46> b1<45> b1<44> b1<43> b1<42> b1<41> b1<40> b1<39> b1<38> b1<37> b1<36> b1<35> b1<34> b1<33> b1<32> b1<31> b1<30> b1<29> b1<28> b1<27> b1<26> b1<25> b1<24> b1<23> b1<22> b1<21> b1<20> b1<19> b1<18> b1<17> b1<16> b1<15> b1<14> b1<13> b1<12> b1<11> b1<10> b1<9> b1<8> b1<7> b1<6> b1<5> b1<4> b1<3> b1<2> b1<1> b1<0> b<191> b<190> b<189> b<188> b<187> b<186> b<185> b<184> b<183> b<182> b<181> b<180> b<179> b<178> b<177> b<176> b<175> b<174> b<173> b<172> b<171> b<170> b<169> b<168> b<167> b<166> b<165> b<164> b<163> b<162> b<161> b<160> b<159> b<158> b<157> b<156> b<155> b<154> b<153> b<152> b<151> b<150> b<149> b<148> b<147> b<146> b<145> b<144> b<143> b<142> b<141> b<140> b<139> b<138> b<137> b<136> b<135> b<134> b<133> b<132> b<131> b<130> b<129> b<128> b<127> b<126> b<125> b<124> b<123> b<122> b<121> b<120> b<119> b<118> b<117> b<116> b<115> b<114> b<113> b<112> b<111> b<110> b<109> b<108> b<107> b<106>
+b<105> b<104> b<103> b<102> b<101> b<100> b<99> b<98> b<97> b<96> b<95> b<94> b<93> b<92> b<91> b<90> b<89> b<88> b<87> b<86> b<85> b<84> b<83> b<82> b<81> b<80> b<79> b<78> b<77> b<76> b<75> b<74> b<73> b<72> b<71> b<70> b<69> b<68> b<67> b<66> b<65> b<64> b<63> b<62> b<61> b<60> b<59> b<58> b<57> b<56> b<55> b<54> b<53> b<52> b<51> b<50> b<49> b<48> b<47> b<46> b<45> b<44> b<43> b<42> b<41> b<40> b<39> b<38> b<37> b<36> b<35> b<34> b<33> b<32> b<31> b<30> b<29> b<28> b<27> b<26> b<25> b<24> b<23> b<22> b<21> b<20> b<19> b<18> b<17> b<16> b<15> b<14> b<13> b<12> b<11> b<10> b<9> b<8> b<7> b<6> b<5> b<4> b<3> b<2> b<1> b<0> SRAM_192
xi6 wl<29> b1<191> b1<190> b1<189> b1<188> b1<187> b1<186> b1<185> b1<184> b1<183> b1<182> b1<181> b1<180> b1<179> b1<178> b1<177> b1<176> b1<175> b1<174> b1<173> b1<172> b1<171> b1<170> b1<169> b1<168> b1<167> b1<166> b1<165> b1<164> b1<163> b1<162> b1<161> b1<160> b1<159> b1<158> b1<157> b1<156> b1<155> b1<154> b1<153> b1<152> b1<151> b1<150> b1<149> b1<148> b1<147> b1<146> b1<145> b1<144> b1<143> b1<142> b1<141> b1<140> b1<139> b1<138> b1<137> b1<136> b1<135> b1<134> b1<133> b1<132> b1<131> b1<130> b1<129> b1<128> b1<127> b1<126> b1<125> b1<124> b1<123> b1<122> b1<121> b1<120> b1<119> b1<118> b1<117> b1<116> b1<115> b1<114> b1<113> b1<112> b1<111> b1<110> b1<109> b1<108> b1<107> b1<106> b1<105> b1<104> b1<103> b1<102> b1<101> b1<100> b1<99> b1<98> b1<97> b1<96> b1<95> b1<94> b1<93> b1<92> b1<91> b1<90> b1<89> b1<88> b1<87> b1<86> b1<85> b1<84> b1<83> b1<82> b1<81> b1<80> b1<79> b1<78> b1<77> b1<76> b1<75> b1<74> b1<73> b1<72> b1<71> b1<70> b1<69> b1<68> b1<67> b1<66> b1<65> b1<64> b1<63> b1<62> b1<61>
+b1<60> b1<59> b1<58> b1<57> b1<56> b1<55> b1<54> b1<53> b1<52> b1<51> b1<50> b1<49> b1<48> b1<47> b1<46> b1<45> b1<44> b1<43> b1<42> b1<41> b1<40> b1<39> b1<38> b1<37> b1<36> b1<35> b1<34> b1<33> b1<32> b1<31> b1<30> b1<29> b1<28> b1<27> b1<26> b1<25> b1<24> b1<23> b1<22> b1<21> b1<20> b1<19> b1<18> b1<17> b1<16> b1<15> b1<14> b1<13> b1<12> b1<11> b1<10> b1<9> b1<8> b1<7> b1<6> b1<5> b1<4> b1<3> b1<2> b1<1> b1<0> b<191> b<190> b<189> b<188> b<187> b<186> b<185> b<184> b<183> b<182> b<181> b<180> b<179> b<178> b<177> b<176> b<175> b<174> b<173> b<172> b<171> b<170> b<169> b<168> b<167> b<166> b<165> b<164> b<163> b<162> b<161> b<160> b<159> b<158> b<157> b<156> b<155> b<154> b<153> b<152> b<151> b<150> b<149> b<148> b<147> b<146> b<145> b<144> b<143> b<142> b<141> b<140> b<139> b<138> b<137> b<136> b<135> b<134> b<133> b<132> b<131> b<130> b<129> b<128> b<127> b<126> b<125> b<124> b<123> b<122> b<121> b<120> b<119> b<118> b<117> b<116> b<115> b<114> b<113> b<112> b<111> b<110> b<109> b<108> b<107> b<106>
+b<105> b<104> b<103> b<102> b<101> b<100> b<99> b<98> b<97> b<96> b<95> b<94> b<93> b<92> b<91> b<90> b<89> b<88> b<87> b<86> b<85> b<84> b<83> b<82> b<81> b<80> b<79> b<78> b<77> b<76> b<75> b<74> b<73> b<72> b<71> b<70> b<69> b<68> b<67> b<66> b<65> b<64> b<63> b<62> b<61> b<60> b<59> b<58> b<57> b<56> b<55> b<54> b<53> b<52> b<51> b<50> b<49> b<48> b<47> b<46> b<45> b<44> b<43> b<42> b<41> b<40> b<39> b<38> b<37> b<36> b<35> b<34> b<33> b<32> b<31> b<30> b<29> b<28> b<27> b<26> b<25> b<24> b<23> b<22> b<21> b<20> b<19> b<18> b<17> b<16> b<15> b<14> b<13> b<12> b<11> b<10> b<9> b<8> b<7> b<6> b<5> b<4> b<3> b<2> b<1> b<0> SRAM_192
xi4 wl<31> b1<191> b1<190> b1<189> b1<188> b1<187> b1<186> b1<185> b1<184> b1<183> b1<182> b1<181> b1<180> b1<179> b1<178> b1<177> b1<176> b1<175> b1<174> b1<173> b1<172> b1<171> b1<170> b1<169> b1<168> b1<167> b1<166> b1<165> b1<164> b1<163> b1<162> b1<161> b1<160> b1<159> b1<158> b1<157> b1<156> b1<155> b1<154> b1<153> b1<152> b1<151> b1<150> b1<149> b1<148> b1<147> b1<146> b1<145> b1<144> b1<143> b1<142> b1<141> b1<140> b1<139> b1<138> b1<137> b1<136> b1<135> b1<134> b1<133> b1<132> b1<131> b1<130> b1<129> b1<128> b1<127> b1<126> b1<125> b1<124> b1<123> b1<122> b1<121> b1<120> b1<119> b1<118> b1<117> b1<116> b1<115> b1<114> b1<113> b1<112> b1<111> b1<110> b1<109> b1<108> b1<107> b1<106> b1<105> b1<104> b1<103> b1<102> b1<101> b1<100> b1<99> b1<98> b1<97> b1<96> b1<95> b1<94> b1<93> b1<92> b1<91> b1<90> b1<89> b1<88> b1<87> b1<86> b1<85> b1<84> b1<83> b1<82> b1<81> b1<80> b1<79> b1<78> b1<77> b1<76> b1<75> b1<74> b1<73> b1<72> b1<71> b1<70> b1<69> b1<68> b1<67> b1<66> b1<65> b1<64> b1<63> b1<62> b1<61>
+b1<60> b1<59> b1<58> b1<57> b1<56> b1<55> b1<54> b1<53> b1<52> b1<51> b1<50> b1<49> b1<48> b1<47> b1<46> b1<45> b1<44> b1<43> b1<42> b1<41> b1<40> b1<39> b1<38> b1<37> b1<36> b1<35> b1<34> b1<33> b1<32> b1<31> b1<30> b1<29> b1<28> b1<27> b1<26> b1<25> b1<24> b1<23> b1<22> b1<21> b1<20> b1<19> b1<18> b1<17> b1<16> b1<15> b1<14> b1<13> b1<12> b1<11> b1<10> b1<9> b1<8> b1<7> b1<6> b1<5> b1<4> b1<3> b1<2> b1<1> b1<0> b<191> b<190> b<189> b<188> b<187> b<186> b<185> b<184> b<183> b<182> b<181> b<180> b<179> b<178> b<177> b<176> b<175> b<174> b<173> b<172> b<171> b<170> b<169> b<168> b<167> b<166> b<165> b<164> b<163> b<162> b<161> b<160> b<159> b<158> b<157> b<156> b<155> b<154> b<153> b<152> b<151> b<150> b<149> b<148> b<147> b<146> b<145> b<144> b<143> b<142> b<141> b<140> b<139> b<138> b<137> b<136> b<135> b<134> b<133> b<132> b<131> b<130> b<129> b<128> b<127> b<126> b<125> b<124> b<123> b<122> b<121> b<120> b<119> b<118> b<117> b<116> b<115> b<114> b<113> b<112> b<111> b<110> b<109> b<108> b<107> b<106>
+b<105> b<104> b<103> b<102> b<101> b<100> b<99> b<98> b<97> b<96> b<95> b<94> b<93> b<92> b<91> b<90> b<89> b<88> b<87> b<86> b<85> b<84> b<83> b<82> b<81> b<80> b<79> b<78> b<77> b<76> b<75> b<74> b<73> b<72> b<71> b<70> b<69> b<68> b<67> b<66> b<65> b<64> b<63> b<62> b<61> b<60> b<59> b<58> b<57> b<56> b<55> b<54> b<53> b<52> b<51> b<50> b<49> b<48> b<47> b<46> b<45> b<44> b<43> b<42> b<41> b<40> b<39> b<38> b<37> b<36> b<35> b<34> b<33> b<32> b<31> b<30> b<29> b<28> b<27> b<26> b<25> b<24> b<23> b<22> b<21> b<20> b<19> b<18> b<17> b<16> b<15> b<14> b<13> b<12> b<11> b<10> b<9> b<8> b<7> b<6> b<5> b<4> b<3> b<2> b<1> b<0> SRAM_192
xi37 b1<191> b1<190> b1<189> b1<188> b1<187> b1<186> b1<185> b1<184> b1<183> b1<182> b1<181> b1<180> b1<179> b1<178> b1<177> b1<176> b1<175> b1<174> b1<173> b1<172> b1<171> b1<170> b1<169> b1<168> b1<167> b1<166> b1<165> b1<164> b1<163> b1<162> b1<161> b1<160> b1<159> b1<158> b1<157> b1<156> b1<155> b1<154> b1<153> b1<152> b1<151> b1<150> b1<149> b1<148> b1<147> b1<146> b1<145> b1<144> b1<143> b1<142> b1<141> b1<140> b1<139> b1<138> b1<137> b1<136> b1<135> b1<134> b1<133> b1<132> b1<131> b1<130> b1<129> b1<128> b1<127> b1<126> b1<125> b1<124> b1<123> b1<122> b1<121> b1<120> b1<119> b1<118> b1<117> b1<116> b1<115> b1<114> b1<113> b1<112> b1<111> b1<110> b1<109> b1<108> b1<107> b1<106> b1<105> b1<104> b1<103> b1<102> b1<101> b1<100> b1<99> b1<98> b1<97> b1<96> b1<95> b1<94> b1<93> b1<92> b1<91> b1<90> b1<89> b1<88> b1<87> b1<86> b1<85> b1<84> b1<83> b1<82> b1<81> b1<80> b1<79> b1<78> b1<77> b1<76> b1<75> b1<74> b1<73> b1<72> b1<71> b1<70> b1<69> b1<68> b1<67> b1<66> b1<65> b1<64> b1<63> b1<62> b1<61> b1<60>
+b1<59> b1<58> b1<57> b1<56> b1<55> b1<54> b1<53> b1<52> b1<51> b1<50> b1<49> b1<48> b1<47> b1<46> b1<45> b1<44> b1<43> b1<42> b1<41> b1<40> b1<39> b1<38> b1<37> b1<36> b1<35> b1<34> b1<33> b1<32> b1<31> b1<30> b1<29> b1<28> b1<27> b1<26> b1<25> b1<24> b1<23> b1<22> b1<21> b1<20> b1<19> b1<18> b1<17> b1<16> b1<15> b1<14> b1<13> b1<12> b1<11> b1<10> b1<9> b1<8> b1<7> b1<6> b1<5> b1<4> b1<3> b1<2> b1<1> b1<0> b<191> b<190> b<189> b<188> b<187> b<186> b<185> b<184> b<183> b<182> b<181> b<180> b<179> b<178> b<177> b<176> b<175> b<174> b<173> b<172> b<171> b<170> b<169> b<168> b<167> b<166> b<165> b<164> b<163> b<162> b<161> b<160> b<159> b<158> b<157> b<156> b<155> b<154> b<153> b<152> b<151> b<150> b<149> b<148> b<147> b<146> b<145> b<144> b<143> b<142> b<141> b<140> b<139> b<138> b<137> b<136> b<135> b<134> b<133> b<132> b<131> b<130> b<129> b<128> b<127> b<126> b<125> b<124> b<123> b<122> b<121> b<120> b<119> b<118> b<117> b<116> b<115> b<114> b<113> b<112> b<111> b<110> b<109> b<108> b<107> b<106> b<105>
+b<104> b<103> b<102> b<101> b<100> b<99> b<98> b<97> b<96> b<95> b<94> b<93> b<92> b<91> b<90> b<89> b<88> b<87> b<86> b<85> b<84> b<83> b<82> b<81> b<80> b<79> b<78> b<77> b<76> b<75> b<74> b<73> b<72> b<71> b<70> b<69> b<68> b<67> b<66> b<65> b<64> b<63> b<62> b<61> b<60> b<59> b<58> b<57> b<56> b<55> b<54> b<53> b<52> b<51> b<50> b<49> b<48> b<47> b<46> b<45> b<44> b<43> b<42> b<41> b<40> b<39> b<38> b<37> b<36> b<35> b<34> b<33> b<32> b<31> b<30> b<29> b<28> b<27> b<26> b<25> b<24> b<23> b<22> b<21> b<20> b<19> b<18> b<17> b<16> b<15> b<14> b<13> b<12> b<11> b<10> b<9> b<8> b<7> b<6> b<5> b<4> b<3> b<2> b<1> b<0> write_data<191> write_data<190> write_data<189> write_data<188> write_data<187> write_data<186> write_data<185> write_data<184> write_data<183> write_data<182> write_data<181> write_data<180> write_data<179> write_data<178> write_data<177> write_data<176> write_data<175> write_data<174> write_data<173> write_data<172> write_data<171> write_data<170> write_data<169> write_data<168>
+write_data<167> write_data<166> write_data<165> write_data<164> write_data<163> write_data<162> write_data<161> write_data<160> write_data<159> write_data<158> write_data<157> write_data<156> write_data<155> write_data<154> write_data<153> write_data<152> write_data<151> write_data<150> write_data<149> write_data<148> write_data<147> write_data<146> write_data<145> write_data<144> write_data<143> write_data<142> write_data<141> write_data<140> write_data<139> write_data<138> write_data<137> write_data<136> write_data<135> write_data<134> write_data<133> write_data<132> write_data<131> write_data<130> write_data<129> write_data<128> write_data<127> write_data<126> write_data<125> write_data<124> write_data<123> write_data<122> write_data<121> write_data<120> write_data<119> write_data<118> write_data<117> write_data<116> write_data<115> write_data<114> write_data<113> write_data<112> write_data<111> write_data<110> write_data<109> write_data<108> write_data<107> write_data<106> write_data<105>
+write_data<104> write_data<103> write_data<102> write_data<101> write_data<100> write_data<99> write_data<98> write_data<97> write_data<96> write_data<95> write_data<94> write_data<93> write_data<92> write_data<91> write_data<90> write_data<89> write_data<88> write_data<87> write_data<86> write_data<85> write_data<84> write_data<83> write_data<82> write_data<81> write_data<80> write_data<79> write_data<78> write_data<77> write_data<76> write_data<75> write_data<74> write_data<73> write_data<72> write_data<71> write_data<70> write_data<69> write_data<68> write_data<67> write_data<66> write_data<65> write_data<64> write_data<63> write_data<62> write_data<61> write_data<60> write_data<59> write_data<58> write_data<57> write_data<56> write_data<55> write_data<54> write_data<53> write_data<52> write_data<51> write_data<50> write_data<49> write_data<48> write_data<47> write_data<46> write_data<45> write_data<44> write_data<43> write_data<42> write_data<41> write_data<40> write_data<39> write_data<38>
+write_data<37> write_data<36> write_data<35> write_data<34> write_data<33> write_data<32> write_data<31> write_data<30> write_data<29> write_data<28> write_data<27> write_data<26> write_data<25> write_data<24> write_data<23> write_data<22> write_data<21> write_data<20> write_data<19> write_data<18> write_data<17> write_data<16> write_data<15> write_data<14> write_data<13> write_data<12> write_data<11> write_data<10> write_data<9> write_data<8> write_data<7> write_data<6> write_data<5> write_data<4> write_data<3> write_data<2> write_data<1> write_data<0> write_en write_driver_192
xi38 b1<191> b1<190> b1<189> b1<188> b1<187> b1<186> b1<185> b1<184> b1<183> b1<182> b1<181> b1<180> b1<179> b1<178> b1<177> b1<176> b1<175> b1<174> b1<173> b1<172> b1<171> b1<170> b1<169> b1<168> b1<167> b1<166> b1<165> b1<164> b1<163> b1<162> b1<161> b1<160> b1<159> b1<158> b1<157> b1<156> b1<155> b1<154> b1<153> b1<152> b1<151> b1<150> b1<149> b1<148> b1<147> b1<146> b1<145> b1<144> b1<143> b1<142> b1<141> b1<140> b1<139> b1<138> b1<137> b1<136> b1<135> b1<134> b1<133> b1<132> b1<131> b1<130> b1<129> b1<128> b1<127> b1<126> b1<125> b1<124> b1<123> b1<122> b1<121> b1<120> b1<119> b1<118> b1<117> b1<116> b1<115> b1<114> b1<113> b1<112> b1<111> b1<110> b1<109> b1<108> b1<107> b1<106> b1<105> b1<104> b1<103> b1<102> b1<101> b1<100> b1<99> b1<98> b1<97> b1<96> b1<95> b1<94> b1<93> b1<92> b1<91> b1<90> b1<89> b1<88> b1<87> b1<86> b1<85> b1<84> b1<83> b1<82> b1<81> b1<80> b1<79> b1<78> b1<77> b1<76> b1<75> b1<74> b1<73> b1<72> b1<71> b1<70> b1<69> b1<68> b1<67> b1<66> b1<65> b1<64> b1<63> b1<62> b1<61> b1<60>
+b1<59> b1<58> b1<57> b1<56> b1<55> b1<54> b1<53> b1<52> b1<51> b1<50> b1<49> b1<48> b1<47> b1<46> b1<45> b1<44> b1<43> b1<42> b1<41> b1<40> b1<39> b1<38> b1<37> b1<36> b1<35> b1<34> b1<33> b1<32> b1<31> b1<30> b1<29> b1<28> b1<27> b1<26> b1<25> b1<24> b1<23> b1<22> b1<21> b1<20> b1<19> b1<18> b1<17> b1<16> b1<15> b1<14> b1<13> b1<12> b1<11> b1<10> b1<9> b1<8> b1<7> b1<6> b1<5> b1<4> b1<3> b1<2> b1<1> b1<0> b<191> b<190> b<189> b<188> b<187> b<186> b<185> b<184> b<183> b<182> b<181> b<180> b<179> b<178> b<177> b<176> b<175> b<174> b<173> b<172> b<171> b<170> b<169> b<168> b<167> b<166> b<165> b<164> b<163> b<162> b<161> b<160> b<159> b<158> b<157> b<156> b<155> b<154> b<153> b<152> b<151> b<150> b<149> b<148> b<147> b<146> b<145> b<144> b<143> b<142> b<141> b<140> b<139> b<138> b<137> b<136> b<135> b<134> b<133> b<132> b<131> b<130> b<129> b<128> b<127> b<126> b<125> b<124> b<123> b<122> b<121> b<120> b<119> b<118> b<117> b<116> b<115> b<114> b<113> b<112> b<111> b<110> b<109> b<108> b<107> b<106> b<105>
+b<104> b<103> b<102> b<101> b<100> b<99> b<98> b<97> b<96> b<95> b<94> b<93> b<92> b<91> b<90> b<89> b<88> b<87> b<86> b<85> b<84> b<83> b<82> b<81> b<80> b<79> b<78> b<77> b<76> b<75> b<74> b<73> b<72> b<71> b<70> b<69> b<68> b<67> b<66> b<65> b<64> b<63> b<62> b<61> b<60> b<59> b<58> b<57> b<56> b<55> b<54> b<53> b<52> b<51> b<50> b<49> b<48> b<47> b<46> b<45> b<44> b<43> b<42> b<41> b<40> b<39> b<38> b<37> b<36> b<35> b<34> b<33> b<32> b<31> b<30> b<29> b<28> b<27> b<26> b<25> b<24> b<23> b<22> b<21> b<20> b<19> b<18> b<17> b<16> b<15> b<14> b<13> b<12> b<11> b<10> b<9> b<8> b<7> b<6> b<5> b<4> b<3> b<2> b<1> b<0> read_en read_data<191> read_data<190> read_data<189> read_data<188> read_data<187> read_data<186> read_data<185> read_data<184> read_data<183> read_data<182> read_data<181> read_data<180> read_data<179> read_data<178> read_data<177> read_data<176> read_data<175> read_data<174> read_data<173> read_data<172> read_data<171> read_data<170> read_data<169> read_data<168> read_data<167> read_data<166>
+read_data<165> read_data<164> read_data<163> read_data<162> read_data<161> read_data<160> read_data<159> read_data<158> read_data<157> read_data<156> read_data<155> read_data<154> read_data<153> read_data<152> read_data<151> read_data<150> read_data<149> read_data<148> read_data<147> read_data<146> read_data<145> read_data<144> read_data<143> read_data<142> read_data<141> read_data<140> read_data<139> read_data<138> read_data<137> read_data<136> read_data<135> read_data<134> read_data<133> read_data<132> read_data<131> read_data<130> read_data<129> read_data<128> read_data<127> read_data<126> read_data<125> read_data<124> read_data<123> read_data<122> read_data<121> read_data<120> read_data<119> read_data<118> read_data<117> read_data<116> read_data<115> read_data<114> read_data<113> read_data<112> read_data<111> read_data<110> read_data<109> read_data<108> read_data<107> read_data<106> read_data<105> read_data<104> read_data<103> read_data<102> read_data<101> read_data<100> read_data<99> read_data<98>
+read_data<97> read_data<96> read_data<95> read_data<94> read_data<93> read_data<92> read_data<91> read_data<90> read_data<89> read_data<88> read_data<87> read_data<86> read_data<85> read_data<84> read_data<83> read_data<82> read_data<81> read_data<80> read_data<79> read_data<78> read_data<77> read_data<76> read_data<75> read_data<74> read_data<73> read_data<72> read_data<71> read_data<70> read_data<69> read_data<68> read_data<67> read_data<66> read_data<65> read_data<64> read_data<63> read_data<62> read_data<61> read_data<60> read_data<59> read_data<58> read_data<57> read_data<56> read_data<55> read_data<54> read_data<53> read_data<52> read_data<51> read_data<50> read_data<49> read_data<48> read_data<47> read_data<46> read_data<45> read_data<44> read_data<43> read_data<42> read_data<41> read_data<40> read_data<39> read_data<38> read_data<37> read_data<36> read_data<35> read_data<34> read_data<33> read_data<32> read_data<31> read_data<30> read_data<29> read_data<28> read_data<27> read_data<26> read_data<25>
+read_data<24> read_data<23> read_data<22> read_data<21> read_data<20> read_data<19> read_data<18> read_data<17> read_data<16> read_data<15> read_data<14> read_data<13> read_data<12> read_data<11> read_data<10> read_data<9> read_data<8> read_data<7> read_data<6> read_data<5> read_data<4> read_data<3> read_data<2> read_data<1> read_data<0> sense_b<191> sense_b<190> sense_b<189> sense_b<188> sense_b<187> sense_b<186> sense_b<185> sense_b<184> sense_b<183> sense_b<182> sense_b<181> sense_b<180> sense_b<179> sense_b<178> sense_b<177> sense_b<176> sense_b<175> sense_b<174> sense_b<173> sense_b<172> sense_b<171> sense_b<170> sense_b<169> sense_b<168> sense_b<167> sense_b<166> sense_b<165> sense_b<164> sense_b<163> sense_b<162> sense_b<161> sense_b<160> sense_b<159> sense_b<158> sense_b<157> sense_b<156> sense_b<155> sense_b<154> sense_b<153> sense_b<152> sense_b<151> sense_b<150> sense_b<149> sense_b<148> sense_b<147> sense_b<146> sense_b<145> sense_b<144> sense_b<143> sense_b<142> sense_b<141> sense_b<140>
+sense_b<139> sense_b<138> sense_b<137> sense_b<136> sense_b<135> sense_b<134> sense_b<133> sense_b<132> sense_b<131> sense_b<130> sense_b<129> sense_b<128> sense_b<127> sense_b<126> sense_b<125> sense_b<124> sense_b<123> sense_b<122> sense_b<121> sense_b<120> sense_b<119> sense_b<118> sense_b<117> sense_b<116> sense_b<115> sense_b<114> sense_b<113> sense_b<112> sense_b<111> sense_b<110> sense_b<109> sense_b<108> sense_b<107> sense_b<106> sense_b<105> sense_b<104> sense_b<103> sense_b<102> sense_b<101> sense_b<100> sense_b<99> sense_b<98> sense_b<97> sense_b<96> sense_b<95> sense_b<94> sense_b<93> sense_b<92> sense_b<91> sense_b<90> sense_b<89> sense_b<88> sense_b<87> sense_b<86> sense_b<85> sense_b<84> sense_b<83> sense_b<82> sense_b<81> sense_b<80> sense_b<79> sense_b<78> sense_b<77> sense_b<76> sense_b<75> sense_b<74> sense_b<73> sense_b<72> sense_b<71> sense_b<70> sense_b<69> sense_b<68> sense_b<67> sense_b<66> sense_b<65> sense_b<64> sense_b<63> sense_b<62> sense_b<61> sense_b<60> sense_b<59>
+sense_b<58> sense_b<57> sense_b<56> sense_b<55> sense_b<54> sense_b<53> sense_b<52> sense_b<51> sense_b<50> sense_b<49> sense_b<48> sense_b<47> sense_b<46> sense_b<45> sense_b<44> sense_b<43> sense_b<42> sense_b<41> sense_b<40> sense_b<39> sense_b<38> sense_b<37> sense_b<36> sense_b<35> sense_b<34> sense_b<33> sense_b<32> sense_b<31> sense_b<30> sense_b<29> sense_b<28> sense_b<27> sense_b<26> sense_b<25> sense_b<24> sense_b<23> sense_b<22> sense_b<21> sense_b<20> sense_b<19> sense_b<18> sense_b<17> sense_b<16> sense_b<15> sense_b<14> sense_b<13> sense_b<12> sense_b<11> sense_b<10> sense_b<9> sense_b<8> sense_b<7> sense_b<6> sense_b<5> sense_b<4> sense_b<3> sense_b<2> sense_b<1> sense_b<0> SAdiff_192
.ends SRAM_TOTAL
** End of subcircuit definition.

** Library name: EE213CAN45nm
** Cell name: SRAM_TOTAL_tb
** View name: schematic
xi0 net3 net38<0> net38<1> net38<2> net38<3> net38<4> net38<5> net38<6> net38<7> net38<8> net38<9> net38<10> net38<11> net38<12> net38<13> net38<14> net38<15> net38<16> net38<17> net38<18> net38<19> net38<20> net38<21> net38<22> net38<23> net38<24> net38<25> net38<26> net38<27> net38<28> net38<29> net38<30> net38<31> net38<32> net38<33> net38<34> net38<35> net38<36> net38<37> net38<38> net38<39> net38<40> net38<41> net38<42> net38<43> net38<44> net38<45> net38<46> net38<47> net38<48> net38<49> net38<50> net38<51> net38<52> net38<53> net38<54> net38<55> net38<56> net38<57> net38<58> net38<59> net38<60> net38<61> net38<62> net38<63> net38<64> net38<65> net38<66> net38<67> net38<68> net38<69> net38<70> net38<71> net38<72> net38<73> net38<74> net38<75> net38<76> net38<77> net38<78> net38<79> net38<80> net38<81> net38<82> net38<83> net38<84> net38<85> net38<86> net38<87> net38<88> net38<89> net38<90> net38<91> net38<92> net38<93> net38<94> net38<95> net38<96> net38<97> net38<98> net38<99> net38<100> net38<101>
+net38<102> net38<103> net38<104> net38<105> net38<106> net38<107> net38<108> net38<109> net38<110> net38<111> net38<112> net38<113> net38<114> net38<115> net38<116> net38<117> net38<118> net38<119> net38<120> net38<121> net38<122> net38<123> net38<124> net38<125> net38<126> net38<127> net38<128> net38<129> net38<130> net38<131> net38<132> net38<133> net38<134> net38<135> net38<136> net38<137> net38<138> net38<139> net38<140> net38<141> net38<142> net38<143> net38<144> net38<145> net38<146> net38<147> net38<148> net38<149> net38<150> net38<151> net38<152> net38<153> net38<154> net38<155> net38<156> net38<157> net38<158> net38<159> net38<160> net38<161> net38<162> net38<163> net38<164> net38<165> net38<166> net38<167> net38<168> net38<169> net38<170> net38<171> net38<172> net38<173> net38<174> net38<175> net38<176> net38<177> net38<178> net38<179> net38<180> net38<181> net38<182> net38<183> net38<184> net38<185> net38<186> net38<187> net38<188> net38<189> net38<190> net38<191> net4 net14 net15 net16 net17
+net18 net19 net20 net21 net22 net23 net5 net24 net25 net26 net27 net28 net29 net30 net31 net32 net33 net6 net34 net35 net7 net8 net9 net10 net11 net12 net13 net36<0> net36<1> net36<2> net36<3> net36<4> net36<5> net36<6> net36<7> net36<8> net36<9> net36<10> net36<11> net36<12> net36<13> net36<14> net36<15> net36<16> net36<17> net36<18> net36<19> net36<20> net36<21> net36<22> net36<23> net36<24> net36<25> net36<26> net36<27> net36<28> net36<29> net36<30> net36<31> net36<32> net36<33> net36<34> net36<35> net36<36> net36<37> net36<38> net36<39> net36<40> net36<41> net36<42> net36<43> net36<44> net36<45> net36<46> net36<47> net36<48> net36<49> net36<50> net36<51> net36<52> net36<53> net36<54> net36<55> net36<56> net36<57> net36<58> net36<59> net36<60> net36<61> net36<62> net36<63> net36<64> net36<65> net36<66> net36<67> net36<68> net36<69> net36<70> net36<71> net36<72> net36<73> net36<74> net36<75> net36<76> net36<77> net36<78> net36<79> net36<80> net36<81> net36<82> net36<83> net36<84> net36<85> net36<86>
+net36<87> net36<88> net36<89> net36<90> net36<91> net36<92> net36<93> net36<94> net36<95> net36<96> net36<97> net36<98> net36<99> net36<100> net36<101> net36<102> net36<103> net36<104> net36<105> net36<106> net36<107> net36<108> net36<109> net36<110> net36<111> net36<112> net36<113> net36<114> net36<115> net36<116> net36<117> net36<118> net36<119> net36<120> net36<121> net36<122> net36<123> net36<124> net36<125> net36<126> net36<127> net36<128> net36<129> net36<130> net36<131> net36<132> net36<133> net36<134> net36<135> net36<136> net36<137> net36<138> net36<139> net36<140> net36<141> net36<142> net36<143> net36<144> net36<145> net36<146> net36<147> net36<148> net36<149> net36<150> net36<151> net36<152> net36<153> net36<154> net36<155> net36<156> net36<157> net36<158> net36<159> net36<160> net36<161> net36<162> net36<163> net36<164> net36<165> net36<166> net36<167> net36<168> net36<169> net36<170> net36<171> net36<172> net36<173> net36<174> net36<175> net36<176> net36<177> net36<178> net36<179> net36<180>
+net36<181> net36<182> net36<183> net36<184> net36<185> net36<186> net36<187> net36<188> net36<189> net36<190> net36<191> net2 net37<0> net37<1> net37<2> net37<3> net37<4> net37<5> net37<6> net37<7> net37<8> net37<9> net37<10> net37<11> net37<12> net37<13> net37<14> net37<15> net37<16> net37<17> net37<18> net37<19> net37<20> net37<21> net37<22> net37<23> net37<24> net37<25> net37<26> net37<27> net37<28> net37<29> net37<30> net37<31> net37<32> net37<33> net37<34> net37<35> net37<36> net37<37> net37<38> net37<39> net37<40> net37<41> net37<42> net37<43> net37<44> net37<45> net37<46> net37<47> net37<48> net37<49> net37<50> net37<51> net37<52> net37<53> net37<54> net37<55> net37<56> net37<57> net37<58> net37<59> net37<60> net37<61> net37<62> net37<63> net37<64> net37<65> net37<66> net37<67> net37<68> net37<69> net37<70> net37<71> net37<72> net37<73> net37<74> net37<75> net37<76> net37<77> net37<78> net37<79> net37<80> net37<81> net37<82> net37<83> net37<84> net37<85> net37<86> net37<87> net37<88> net37<89>
+net37<90> net37<91> net37<92> net37<93> net37<94> net37<95> net37<96> net37<97> net37<98> net37<99> net37<100> net37<101> net37<102> net37<103> net37<104> net37<105> net37<106> net37<107> net37<108> net37<109> net37<110> net37<111> net37<112> net37<113> net37<114> net37<115> net37<116> net37<117> net37<118> net37<119> net37<120> net37<121> net37<122> net37<123> net37<124> net37<125> net37<126> net37<127> net37<128> net37<129> net37<130> net37<131> net37<132> net37<133> net37<134> net37<135> net37<136> net37<137> net37<138> net37<139> net37<140> net37<141> net37<142> net37<143> net37<144> net37<145> net37<146> net37<147> net37<148> net37<149> net37<150> net37<151> net37<152> net37<153> net37<154> net37<155> net37<156> net37<157> net37<158> net37<159> net37<160> net37<161> net37<162> net37<163> net37<164> net37<165> net37<166> net37<167> net37<168> net37<169> net37<170> net37<171> net37<172> net37<173> net37<174> net37<175> net37<176> net37<177> net37<178> net37<179> net37<180> net37<181> net37<182>
+net37<183> net37<184> net37<185> net37<186> net37<187> net37<188> net37<189> net37<190> net37<191> net1 SRAM_TOTAL
.END
