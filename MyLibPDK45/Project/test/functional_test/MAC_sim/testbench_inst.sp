** Library name: mycells45
** Cell name: MAC_64_3bit*4bit_test
** View name: schematic

** test rom
xmultiplier multiplier<0> multiplier<1> multiplier<2> multiplier<3> multiplier<4> multiplier<5> multiplier<6> multiplier<7> multiplier<8> multiplier<9> multiplier<10>
+ multiplier<11> multiplier<12> multiplier<13> multiplier<14> multiplier<15> multiplier<16> multiplier<17> multiplier<18> multiplier<19> multiplier<20> multiplier<21> multiplier<22> multiplier<23> multiplier<24> multiplier<25> multiplier<26>
+ multiplier<27> multiplier<28> multiplier<29> multiplier<30> multiplier<31> multiplier<32> multiplier<33> multiplier<34> multiplier<35> multiplier<36> multiplier<37> multiplier<38> multiplier<39> multiplier<40> multiplier<41> multiplier<42>
+ multiplier<43> multiplier<44> multiplier<45> multiplier<46> multiplier<47> multiplier<48> multiplier<49> multiplier<50> multiplier<51> multiplier<52> multiplier<53> multiplier<54> multiplier<55> multiplier<56> multiplier<57> multiplier<58>
+ multiplier<59> multiplier<60> multiplier<61> multiplier<62> multiplier<63> multiplier<64> multiplier<65> multiplier<66> multiplier<67> multiplier<68> multiplier<69> multiplier<70> multiplier<71> multiplier<72> multiplier<73> multiplier<74>
+ multiplier<75> multiplier<76> multiplier<77> multiplier<78> multiplier<79> multiplier<80> multiplier<81> multiplier<82> multiplier<83> multiplier<84> multiplier<85> multiplier<86> multiplier<87> multiplier<88> multiplier<89> multiplier<90>
+ multiplier<91> multiplier<92> multiplier<93> multiplier<94> multiplier<95> multiplier<96> multiplier<97> multiplier<98> multiplier<99> multiplier<100> multiplier<101> multiplier<102> multiplier<103> multiplier<104> multiplier<105> multiplier<106>
+ multiplier<107> multiplier<108> multiplier<109> multiplier<110> multiplier<111> multiplier<112> multiplier<113> multiplier<114> multiplier<115> multiplier<116> multiplier<117> multiplier<118> multiplier<119> multiplier<120> multiplier<121> multiplier<122>
+ multiplier<123> multiplier<124> multiplier<125> multiplier<126> multiplier<127> multiplier<128> multiplier<129> multiplier<130> multiplier<131> multiplier<132> multiplier<133> multiplier<134> multiplier<135> multiplier<136> multiplier<137> multiplier<138>
+ multiplier<139> multiplier<140> multiplier<141> multiplier<142> multiplier<143> multiplier<144> multiplier<145> multiplier<146> multiplier<147> multiplier<148> multiplier<149> multiplier<150> multiplier<151> multiplier<152> multiplier<153> multiplier<154>
+ multiplier<155> multiplier<156> multiplier<157> multiplier<158> multiplier<159> multiplier<160> multiplier<161> multiplier<162> multiplier<163> multiplier<164> multiplier<165> multiplier<166> multiplier<167> multiplier<168> multiplier<169> multiplier<170>
+ multiplier<171> multiplier<172> multiplier<173> multiplier<174> multiplier<175> multiplier<176> multiplier<177> multiplier<178> multiplier<179> multiplier<180> multiplier<181> multiplier<182> multiplier<183> multiplier<184> multiplier<185> multiplier<186>
+ multiplier<187> multiplier<188> multiplier<189> multiplier<190> multiplier<191> multiplier_src vdd_val=vdd_val period=period

xmultiplicand multiplicand<0> multiplicand<1> multiplicand<2> multiplicand<3> multiplicand<4> multiplicand<5> multiplicand<6> multiplicand<7> multiplicand<8> multiplicand<9> multiplicand<10> multiplicand<11> multiplicand<12> multiplicand<13> multiplicand<14>
+ multiplicand<15> multiplicand<16> multiplicand<17> multiplicand<18> multiplicand<19> multiplicand<20> multiplicand<21> multiplicand<22> multiplicand<23> multiplicand<24> multiplicand<25> multiplicand<26> multiplicand<27> multiplicand<28> multiplicand<29> multiplicand<30>
+ multiplicand<31> multiplicand<32> multiplicand<33> multiplicand<34> multiplicand<35> multiplicand<36> multiplicand<37> multiplicand<38> multiplicand<39> multiplicand<40> multiplicand<41> multiplicand<42> multiplicand<43> multiplicand<44> multiplicand<45> multiplicand<46>
+ multiplicand<47> multiplicand<48> multiplicand<49> multiplicand<50> multiplicand<51> multiplicand<52> multiplicand<53> multiplicand<54> multiplicand<55> multiplicand<56> multiplicand<57> multiplicand<58> multiplicand<59> multiplicand<60> multiplicand<61> multiplicand<62>
+ multiplicand<63> multiplicand<64> multiplicand<65> multiplicand<66> multiplicand<67> multiplicand<68> multiplicand<69> multiplicand<70> multiplicand<71> multiplicand<72> multiplicand<73> multiplicand<74> multiplicand<75> multiplicand<76> multiplicand<77> multiplicand<78>
+ multiplicand<79> multiplicand<80> multiplicand<81> multiplicand<82> multiplicand<83> multiplicand<84> multiplicand<85> multiplicand<86> multiplicand<87> multiplicand<88> multiplicand<89> multiplicand<90> multiplicand<91> multiplicand<92> multiplicand<93> multiplicand<94>
+ multiplicand<95> multiplicand<96> multiplicand<97> multiplicand<98> multiplicand<99> multiplicand<100> multiplicand<101> multiplicand<102> multiplicand<103> multiplicand<104> multiplicand<105> multiplicand<106> multiplicand<107> multiplicand<108> multiplicand<109> multiplicand<110>
+ multiplicand<111> multiplicand<112> multiplicand<113> multiplicand<114> multiplicand<115> multiplicand<116> multiplicand<117> multiplicand<118> multiplicand<119> multiplicand<120> multiplicand<121> multiplicand<122> multiplicand<123> multiplicand<124> multiplicand<125> multiplicand<126>
+ multiplicand<127> multiplicand<128> multiplicand<129> multiplicand<130> multiplicand<131> multiplicand<132> multiplicand<133> multiplicand<134> multiplicand<135> multiplicand<136> multiplicand<137> multiplicand<138> multiplicand<139> multiplicand<140> multiplicand<141> multiplicand<142>
+ multiplicand<143> multiplicand<144> multiplicand<145> multiplicand<146> multiplicand<147> multiplicand<148> multiplicand<149> multiplicand<150> multiplicand<151> multiplicand<152> multiplicand<153> multiplicand<154> multiplicand<155> multiplicand<156> multiplicand<157> multiplicand<158>
+ multiplicand<159> multiplicand<160> multiplicand<161> multiplicand<162> multiplicand<163> multiplicand<164> multiplicand<165> multiplicand<166> multiplicand<167> multiplicand<168> multiplicand<169> multiplicand<170> multiplicand<171> multiplicand<172> multiplicand<173> multiplicand<174>
+ multiplicand<175> multiplicand<176> multiplicand<177> multiplicand<178> multiplicand<179> multiplicand<180> multiplicand<181> multiplicand<182> multiplicand<183> multiplicand<184> multiplicand<185> multiplicand<186> multiplicand<187> multiplicand<188> multiplicand<189> multiplicand<190>
+ multiplicand<191> multiplicand<192> multiplicand<193> multiplicand<194> multiplicand<195> multiplicand<196> multiplicand<197> multiplicand<198> multiplicand<199> multiplicand<200> multiplicand<201> multiplicand<202> multiplicand<203> multiplicand<204> multiplicand<205> multiplicand<206>
+ multiplicand<207> multiplicand<208> multiplicand<209> multiplicand<210> multiplicand<211> multiplicand<212> multiplicand<213> multiplicand<214> multiplicand<215> multiplicand<216> multiplicand<217> multiplicand<218> multiplicand<219> multiplicand<220> multiplicand<221> multiplicand<222>
+ multiplicand<223> multiplicand<224> multiplicand<225> multiplicand<226> multiplicand<227> multiplicand<228> multiplicand<229> multiplicand<230> multiplicand<231> multiplicand<232> multiplicand<233> multiplicand<234> multiplicand<235> multiplicand<236> multiplicand<237> multiplicand<238>
+ multiplicand<239> multiplicand<240> multiplicand<241> multiplicand<242> multiplicand<243> multiplicand<244> multiplicand<245> multiplicand<246> multiplicand<247> multiplicand<248> multiplicand<249> multiplicand<250> multiplicand<251> multiplicand<252> multiplicand<253> multiplicand<254>
+ multiplicand<255> multiplicand_src vdd_val=vdd_val period=period

v0 vdd! 0 DC=vdd_val
vclk clk 0 PULSE 0 vdd_val 0 0 0 'period/2' 'period'
c0<11> result<11> 0 40e-15
c0<10> result<10> 0 40e-15
c0<9> result<9> 0 40e-15
c0<8> result<8> 0 40e-15
c0<7> result<7> 0 40e-15
c0<6> result<6> 0 40e-15
c0<5> result<5> 0 40e-15
c0<4> result<4> 0 40e-15
c0<3> result<3> 0 40e-15
c0<2> result<2> 0 40e-15
c0<1> result<1> 0 40e-15
c0<0> result<0> 0 40e-15
