.GLOBAL vdd!
.PARAM vdd_val=0.7 period=5n

.TEMP 25.0
.OPTION
+    INGOLD=2
+    PARHIER=LOCAL
+    POST=2
+    PROBE
+    NOMOD

.TRAN 1e-12 'period*64' START=0.0

.PROBE TRAN
+    V(sram_ren)
+    V(sram_wen)
+    V(addr<0>)
+    V(addr<1>)
+    V(addr<2>)
+    V(addr<3>)
+    V(addr<4>)
+    V(data<0>)
+    V(data<1>)
+    V(data<2>)
+    V(data<3>)
+    V(data<4>)
+    V(data<5>)
+    V(data<6>)
+    V(data<7>)
+    V(data<8>)
+    V(data<9>)
+    V(data<10>)
+    V(data<11>)
+    V(data<12>)
+    V(data<13>)
+    V(data<14>)
+    V(data<15>)
+    V(data<16>)
+    V(data<17>)
+    V(data<18>)
+    V(data<19>)
+    V(data<20>)
+    V(data<21>)
+    V(data<22>)
+    V(data<23>)
.PROBE TRAN
+    V(data<24>)
+    V(data<25>)
+    V(data<26>)
+    V(data<27>)
+    V(data<28>)
+    V(data<29>)
+    V(data<30>)
+    V(data<31>)
+    V(data<32>)
+    V(data<33>)
+    V(data<34>)
+    V(data<35>)
+    V(data<36>)
+    V(data<37>)
+    V(data<38>)
+    V(data<39>)
+    V(data<40>)
+    V(data<41>)
+    V(data<42>)
+    V(data<43>)
+    V(data<44>)
+    V(data<45>)
+    V(data<46>)
+    V(data<47>)
+    V(data<48>)
+    V(data<49>)
+    V(data<50>)
+    V(data<51>)
+    V(data<52>)
+    V(data<53>)
+    V(data<54>)
+    V(data<55>)
.PROBE TRAN
+    V(data<56>)
+    V(data<57>)
+    V(data<58>)
+    V(data<59>)
+    V(data<60>)
+    V(data<61>)
+    V(data<62>)
+    V(data<63>)
+    V(data<64>)
+    V(data<65>)
+    V(data<66>)
+    V(data<67>)
+    V(data<68>)
+    V(data<69>)
+    V(data<70>)
+    V(data<71>)
+    V(data<72>)
+    V(data<73>)
+    V(data<74>)
+    V(data<75>)
+    V(data<76>)
+    V(data<77>)
+    V(data<78>)
+    V(data<79>)
+    V(data<80>)
+    V(data<81>)
+    V(data<82>)
+    V(data<83>)
+    V(data<84>)
+    V(data<85>)
+    V(data<86>)
+    V(data<87>)
.PROBE TRAN
+    V(data<88>)
+    V(data<89>)
+    V(data<90>)
+    V(data<91>)
+    V(data<92>)
+    V(data<93>)
+    V(data<94>)
+    V(data<95>)
+    V(data<96>)
+    V(data<97>)
+    V(data<98>)
+    V(data<99>)
+    V(data<100>)
+    V(data<101>)
+    V(data<102>)
+    V(data<103>)
+    V(data<104>)
+    V(data<105>)
+    V(data<106>)
+    V(data<107>)
+    V(data<108>)
+    V(data<109>)
+    V(data<110>)
+    V(data<111>)
+    V(data<112>)
+    V(data<113>)
+    V(data<114>)
+    V(data<115>)
+    V(data<116>)
+    V(data<117>)
+    V(data<118>)
+    V(data<119>)
.PROBE TRAN
+    V(data<120>)
+    V(data<121>)
+    V(data<122>)
+    V(data<123>)
+    V(data<124>)
+    V(data<125>)
+    V(data<126>)
+    V(data<127>)
+    V(data<128>)
+    V(data<129>)
+    V(data<130>)
+    V(data<131>)
+    V(data<132>)
+    V(data<133>)
+    V(data<134>)
+    V(data<135>)
+    V(data<136>)
+    V(data<137>)
+    V(data<138>)
+    V(data<139>)
+    V(data<140>)
+    V(data<141>)
+    V(data<142>)
+    V(data<143>)
+    V(data<144>)
+    V(data<145>)
+    V(data<146>)
+    V(data<147>)
+    V(data<148>)
+    V(data<149>)
+    V(data<150>)
+    V(data<151>)
.PROBE TRAN
+    V(data<152>)
+    V(data<153>)
+    V(data<154>)
+    V(data<155>)
+    V(data<156>)
+    V(data<157>)
+    V(data<158>)
+    V(data<159>)
+    V(data<160>)
+    V(data<161>)
+    V(data<162>)
+    V(data<163>)
+    V(data<164>)
+    V(data<165>)
+    V(data<166>)
+    V(data<167>)
+    V(data<168>)
+    V(data<169>)
+    V(data<170>)
+    V(data<171>)
+    V(data<172>)
+    V(data<173>)
+    V(data<174>)
+    V(data<175>)
+    V(data<176>)
+    V(data<177>)
+    V(data<178>)
+    V(data<179>)
+    V(data<180>)
+    V(data<181>)
+    V(data<182>)
+    V(data<183>)
.PROBE TRAN
+    V(data<184>)
+    V(data<185>)
+    V(data<186>)
+    V(data<187>)
+    V(data<188>)
+    V(data<189>)
+    V(data<190>)
+    V(data<191>)
+    V(data_read<0>)
+    V(data_read<1>)
+    V(data_read<2>)
+    V(data_read<3>)
+    V(data_read<4>)
+    V(data_read<5>)
+    V(data_read<6>)
+    V(data_read<7>)
+    V(data_read<8>)
+    V(data_read<9>)
+    V(data_read<10>)
+    V(data_read<11>)
+    V(data_read<12>)
+    V(data_read<13>)
+    V(data_read<14>)
+    V(data_read<15>)
+    V(data_read<16>)
+    V(data_read<17>)
+    V(data_read<18>)
+    V(data_read<19>)
+    V(data_read<20>)
+    V(data_read<21>)
+    V(data_read<22>)
+    V(data_read<23>)
.PROBE TRAN
+    V(data_read<24>)
+    V(data_read<25>)
+    V(data_read<26>)
+    V(data_read<27>)
+    V(data_read<28>)
+    V(data_read<29>)
+    V(data_read<30>)
+    V(data_read<31>)
+    V(data_read<32>)
+    V(data_read<33>)
+    V(data_read<34>)
+    V(data_read<35>)
+    V(data_read<36>)
+    V(data_read<37>)
+    V(data_read<38>)
+    V(data_read<39>)
+    V(data_read<40>)
+    V(data_read<41>)
+    V(data_read<42>)
+    V(data_read<43>)
+    V(data_read<44>)
+    V(data_read<45>)
+    V(data_read<46>)
+    V(data_read<47>)
+    V(data_read<48>)
+    V(data_read<49>)
+    V(data_read<50>)
+    V(data_read<51>)
+    V(data_read<52>)
+    V(data_read<53>)
+    V(data_read<54>)
+    V(data_read<55>)
.PROBE TRAN
+    V(data_read<56>)
+    V(data_read<57>)
+    V(data_read<58>)
+    V(data_read<59>)
+    V(data_read<60>)
+    V(data_read<61>)
+    V(data_read<62>)
+    V(data_read<63>)
+    V(data_read<64>)
+    V(data_read<65>)
+    V(data_read<66>)
+    V(data_read<67>)
+    V(data_read<68>)
+    V(data_read<69>)
+    V(data_read<70>)
+    V(data_read<71>)
+    V(data_read<72>)
+    V(data_read<73>)
+    V(data_read<74>)
+    V(data_read<75>)
+    V(data_read<76>)
+    V(data_read<77>)
+    V(data_read<78>)
+    V(data_read<79>)
+    V(data_read<80>)
+    V(data_read<81>)
+    V(data_read<82>)
+    V(data_read<83>)
+    V(data_read<84>)
+    V(data_read<85>)
+    V(data_read<86>)
+    V(data_read<87>)
.PROBE TRAN
+    V(data_read<88>)
+    V(data_read<89>)
+    V(data_read<90>)
+    V(data_read<91>)
+    V(data_read<92>)
+    V(data_read<93>)
+    V(data_read<94>)
+    V(data_read<95>)
+    V(data_read<96>)
+    V(data_read<97>)
+    V(data_read<98>)
+    V(data_read<99>)
+    V(data_read<100>)
+    V(data_read<101>)
+    V(data_read<102>)
+    V(data_read<103>)
+    V(data_read<104>)
+    V(data_read<105>)
+    V(data_read<106>)
+    V(data_read<107>)
+    V(data_read<108>)
+    V(data_read<109>)
+    V(data_read<110>)
+    V(data_read<111>)
+    V(data_read<112>)
+    V(data_read<113>)
+    V(data_read<114>)
+    V(data_read<115>)
+    V(data_read<116>)
+    V(data_read<117>)
+    V(data_read<118>)
+    V(data_read<119>)
.PROBE TRAN
+    V(data_read<120>)
+    V(data_read<121>)
+    V(data_read<122>)
+    V(data_read<123>)
+    V(data_read<124>)
+    V(data_read<125>)
+    V(data_read<126>)
+    V(data_read<127>)
+    V(data_read<128>)
+    V(data_read<129>)
+    V(data_read<130>)
+    V(data_read<131>)
+    V(data_read<132>)
+    V(data_read<133>)
+    V(data_read<134>)
+    V(data_read<135>)
+    V(data_read<136>)
+    V(data_read<137>)
+    V(data_read<138>)
+    V(data_read<139>)
+    V(data_read<140>)
+    V(data_read<141>)
+    V(data_read<142>)
+    V(data_read<143>)
+    V(data_read<144>)
+    V(data_read<145>)
+    V(data_read<146>)
+    V(data_read<147>)
+    V(data_read<148>)
+    V(data_read<149>)
+    V(data_read<150>)
+    V(data_read<151>)
.PROBE TRAN
+    V(data_read<152>)
+    V(data_read<153>)
+    V(data_read<154>)
+    V(data_read<155>)
+    V(data_read<156>)
+    V(data_read<157>)
+    V(data_read<158>)
+    V(data_read<159>)
+    V(data_read<160>)
+    V(data_read<161>)
+    V(data_read<162>)
+    V(data_read<163>)
+    V(data_read<164>)
+    V(data_read<165>)
+    V(data_read<166>)
+    V(data_read<167>)
+    V(data_read<168>)
+    V(data_read<169>)
+    V(data_read<170>)
+    V(data_read<171>)
+    V(data_read<172>)
+    V(data_read<173>)
+    V(data_read<174>)
+    V(data_read<175>)
+    V(data_read<176>)
+    V(data_read<177>)
+    V(data_read<178>)
+    V(data_read<179>)
+    V(data_read<180>)
+    V(data_read<181>)
+    V(data_read<182>)
+    V(data_read<183>)
.PROBE TRAN
+    V(data_read<184>)
+    V(data_read<185>)
+    V(data_read<186>)
+    V(data_read<187>)
+    V(data_read<188>)
+    V(data_read<189>)
+    V(data_read<190>)
+    V(data_read<191>)
+    V(prc)
