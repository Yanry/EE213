** Multiplication & Addition Module

** Include VMA netlist
.INCLUDE "MAC.sp"

***********************************
* Set period time here
***********************************
.PARAM
+ period = 5n

** Instantiate your MAC module here
*   The MAC module does vector inner product of two 64d vectors. The multiplier(i.e. weight) and multiplicand(i.e. input) is
*   quantized to 3bit and 4bit signed integer respectively. The output is a single 12bit signed integer.
*	The following content describes the pins needed in MAC module and the corresponding internal signals they should be connected to
*	Format:
*		<module_pin_name> -> <testbench_signal_name> : <description>
*		"->" means connect to
*
*	Your top module should have the following pins
*	Output:
*       OUT<11:0> -> result<11:0>: The output result of MAC module
*	Inputs:
*       MULTIPLIER<191:0> -> multiplier<191:0>: The 64*3bit multiplier
*       MULTIPLICAND<255:0> -> multiplicand<255:0>: The 64*4bit multiplicand

** Here is an example of the instance. The order of signals may vary with your design.
** Please connect the signals correctly. (Do not modify the instance name when you instantiate your module)
xmac multiplicand<255> multiplicand<254> multiplicand<253> multiplicand<252> multiplicand<251> multiplicand<250> multiplicand<249> multiplicand<248> multiplicand<247> multiplicand<246> multiplicand<245> multiplicand<244> multiplicand<243> multiplicand<242> multiplicand<241> multiplicand<240> multiplicand<239> multiplicand<238> multiplicand<237> multiplicand<236> multiplicand<235> multiplicand<234> multiplicand<233> multiplicand<232> multiplicand<231> multiplicand<230> multiplicand<229> multiplicand<228> multiplicand<227> multiplicand<226> multiplicand<225> multiplicand<224> multiplicand<223> multiplicand<222> multiplicand<221> multiplicand<220> multiplicand<219> multiplicand<218> multiplicand<217> multiplicand<216> multiplicand<215> multiplicand<214> multiplicand<213> multiplicand<212> multiplicand<211> multiplicand<210> multiplicand<209> multiplicand<208> multiplicand<207> multiplicand<206> multiplicand<205> multiplicand<204> multiplicand<203> multiplicand<202> multiplicand<201> multiplicand<200>
+multiplicand<199> multiplicand<198> multiplicand<197> multiplicand<196> multiplicand<195> multiplicand<194> multiplicand<193> multiplicand<192> multiplicand<191> multiplicand<190> multiplicand<189> multiplicand<188> multiplicand<187> multiplicand<186> multiplicand<185> multiplicand<184> multiplicand<183> multiplicand<182> multiplicand<181> multiplicand<180> multiplicand<179> multiplicand<178> multiplicand<177> multiplicand<176> multiplicand<175> multiplicand<174> multiplicand<173> multiplicand<172> multiplicand<171> multiplicand<170> multiplicand<169> multiplicand<168> multiplicand<167> multiplicand<166> multiplicand<165> multiplicand<164> multiplicand<163> multiplicand<162> multiplicand<161> multiplicand<160> multiplicand<159> multiplicand<158> multiplicand<157> multiplicand<156> multiplicand<155> multiplicand<154> multiplicand<153> multiplicand<152> multiplicand<151> multiplicand<150> multiplicand<149> multiplicand<148> multiplicand<147> multiplicand<146> multiplicand<145> multiplicand<144>
+multiplicand<143> multiplicand<142> multiplicand<141> multiplicand<140> multiplicand<139> multiplicand<138> multiplicand<137> multiplicand<136> multiplicand<135> multiplicand<134> multiplicand<133> multiplicand<132> multiplicand<131> multiplicand<130> multiplicand<129> multiplicand<128> multiplicand<127> multiplicand<126> multiplicand<125> multiplicand<124> multiplicand<123> multiplicand<122> multiplicand<121> multiplicand<120> multiplicand<119> multiplicand<118> multiplicand<117> multiplicand<116> multiplicand<115> multiplicand<114> multiplicand<113> multiplicand<112> multiplicand<111> multiplicand<110> multiplicand<109> multiplicand<108> multiplicand<107> multiplicand<106> multiplicand<105> multiplicand<104> multiplicand<103> multiplicand<102> multiplicand<101> multiplicand<100> multiplicand<99> multiplicand<98> multiplicand<97> multiplicand<96> multiplicand<95> multiplicand<94> multiplicand<93> multiplicand<92> multiplicand<91> multiplicand<90> multiplicand<89> multiplicand<88> multiplicand<87>
+multiplicand<86> multiplicand<85> multiplicand<84> multiplicand<83> multiplicand<82> multiplicand<81> multiplicand<80> multiplicand<79> multiplicand<78> multiplicand<77> multiplicand<76> multiplicand<75> multiplicand<74> multiplicand<73> multiplicand<72> multiplicand<71> multiplicand<70> multiplicand<69> multiplicand<68> multiplicand<67> multiplicand<66> multiplicand<65> multiplicand<64> multiplicand<63> multiplicand<62> multiplicand<61> multiplicand<60> multiplicand<59> multiplicand<58> multiplicand<57> multiplicand<56> multiplicand<55> multiplicand<54> multiplicand<53> multiplicand<52> multiplicand<51> multiplicand<50> multiplicand<49> multiplicand<48> multiplicand<47> multiplicand<46> multiplicand<45> multiplicand<44> multiplicand<43> multiplicand<42> multiplicand<41> multiplicand<40> multiplicand<39> multiplicand<38> multiplicand<37> multiplicand<36> multiplicand<35> multiplicand<34> multiplicand<33> multiplicand<32> multiplicand<31> multiplicand<30> multiplicand<29> multiplicand<28> multiplicand<27>
+multiplicand<26> multiplicand<25> multiplicand<24> multiplicand<23> multiplicand<22> multiplicand<21> multiplicand<20> multiplicand<19> multiplicand<18> multiplicand<17> multiplicand<16> multiplicand<15> multiplicand<14> multiplicand<13> multiplicand<12> multiplicand<11> multiplicand<10> multiplicand<9> multiplicand<8> multiplicand<7> multiplicand<6> multiplicand<5> multiplicand<4> multiplicand<3> multiplicand<2> multiplicand<1> multiplicand<0> multiplier<191> multiplier<190> multiplier<189> multiplier<188> multiplier<187> multiplier<186> multiplier<185> multiplier<184> multiplier<183> multiplier<182> multiplier<181> multiplier<180> multiplier<179> multiplier<178> multiplier<177> multiplier<176> multiplier<175> multiplier<174> multiplier<173> multiplier<172> multiplier<171> multiplier<170> multiplier<169> multiplier<168> multiplier<167> multiplier<166> multiplier<165> multiplier<164> multiplier<163> multiplier<162> multiplier<161> multiplier<160> multiplier<159> multiplier<158> multiplier<157>
+multiplier<156> multiplier<155> multiplier<154> multiplier<153> multiplier<152> multiplier<151> multiplier<150> multiplier<149> multiplier<148> multiplier<147> multiplier<146> multiplier<145> multiplier<144> multiplier<143> multiplier<142> multiplier<141> multiplier<140> multiplier<139> multiplier<138> multiplier<137> multiplier<136> multiplier<135> multiplier<134> multiplier<133> multiplier<132> multiplier<131> multiplier<130> multiplier<129> multiplier<128> multiplier<127> multiplier<126> multiplier<125> multiplier<124> multiplier<123> multiplier<122> multiplier<121> multiplier<120> multiplier<119> multiplier<118> multiplier<117> multiplier<116> multiplier<115> multiplier<114> multiplier<113> multiplier<112> multiplier<111> multiplier<110> multiplier<109> multiplier<108> multiplier<107> multiplier<106> multiplier<105> multiplier<104> multiplier<103> multiplier<102> multiplier<101> multiplier<100> multiplier<99> multiplier<98> multiplier<97> multiplier<96> multiplier<95> multiplier<94> multiplier<93>
+multiplier<92> multiplier<91> multiplier<90> multiplier<89> multiplier<88> multiplier<87> multiplier<86> multiplier<85> multiplier<84> multiplier<83> multiplier<82> multiplier<81> multiplier<80> multiplier<79> multiplier<78> multiplier<77> multiplier<76> multiplier<75> multiplier<74> multiplier<73> multiplier<72> multiplier<71> multiplier<70> multiplier<69> multiplier<68> multiplier<67> multiplier<66> multiplier<65> multiplier<64> multiplier<63> multiplier<62> multiplier<61> multiplier<60> multiplier<59> multiplier<58> multiplier<57> multiplier<56> multiplier<55> multiplier<54> multiplier<53> multiplier<52> multiplier<51> multiplier<50> multiplier<49> multiplier<48> multiplier<47> multiplier<46> multiplier<45> multiplier<44> multiplier<43> multiplier<42> multiplier<41> multiplier<40> multiplier<39> multiplier<38> multiplier<37> multiplier<36> multiplier<35> multiplier<34> multiplier<33> multiplier<32> multiplier<31> multiplier<30> multiplier<29> multiplier<28> multiplier<27> multiplier<26> multiplier<25>
+multiplier<24> multiplier<23> multiplier<22> multiplier<21> multiplier<20> multiplier<19> multiplier<18> multiplier<17> multiplier<16> multiplier<15> multiplier<14> multiplier<13> multiplier<12> multiplier<11> multiplier<10> multiplier<9> multiplier<8> multiplier<7> multiplier<6> multiplier<5> multiplier<4> multiplier<3> multiplier<2> multiplier<1> multiplier<0> result<11> result<10> result<9> result<8> result<7> result<6> result<5> result<4> result<3> result<2> result<1> result<0> MAC_64
