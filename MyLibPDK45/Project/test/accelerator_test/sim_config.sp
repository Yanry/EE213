** Param
.GLOBAL vdd!
.PARAM period=8n vdd_val=0.7
.TEMP 25.0
.OPTION
+    INGOLD=2
+    PARHIER=LOCAL
+    POST=2
+    PROBE
+    NOMOD

** Simulation type
.TRAN 1e-12 'period*70' START=0.0

** Probe signals
.PROBE TRAN
+    V(sram_wen)
+    V(sram_ren)
+    V(buffer_init)
+    V(buffer_flip)
+    V(buffer_blk_addr<0>)
+    V(buffer_blk_addr<1>)
+    V(buffer_blk_addr<2>)
+    V(buffer_blk_addr<3>)
+    V(buffer_blk_addr<4>)
+    V(buffer_blk_addr<5>)
+    V(state<0>)
+    V(state<1>)
+    V(state<2>)
+    V(state<3>)
+    V(state<4>)
+    V(state<5>)
+    V(qa<0>)
+    V(qa<1>)
+    V(qa<2>)
+    V(qa<3>)
+    V(mac_out<0>)
+    V(mac_out<1>)
+    V(mac_out<2>)
+    V(mac_out<3>)
+    V(mac_out<4>)
+    V(mac_out<5>)
+    V(mac_out<6>)
+    V(mac_out<7>)
+    V(mac_out<8>)
+    V(mac_out<9>)
+    V(mac_out<10>)
.PROBE TRAN
+    V(mac_out<11>)
+    V(sh<0>)
+    V(sh<1>)
+    V(sh<2>)
+    V(tot_weight_num<0>)
+    V(tot_weight_num<1>)
+    V(tot_weight_num<2>)
+    V(tot_weight_num<3>)
+    V(tot_weight_num<4>)
+    V(l1_weight_num<0>)
+    V(l1_weight_num<1>)
+    V(l1_weight_num<2>)
+    V(l1_weight_num<3>)
+    V(l1_weight_num<4>)
+    V(l2_scale<0>)
+    V(l2_scale<1>)
+    V(l2_scale<2>)
+    V(l1_scale<0>)
+    V(l1_scale<1>)
+    V(l1_scale<2>)
+    V(ready)
+    V(clk)
+    V(start)
+    V(reset)
+    V(prc)
+    V(input<0>)
+    V(input<1>)
+    V(input<2>)
+    V(input<3>)
+    V(input<4>)
+    V(input<5>)
+    V(input<6>)
.PROBE TRAN
+    V(input<7>)
+    V(input<8>)
+    V(input<9>)
+    V(input<10>)
+    V(input<11>)
+    V(input<12>)
+    V(input<13>)
+    V(input<14>)
+    V(input<15>)
+    V(input<16>)
+    V(input<17>)
+    V(input<18>)
+    V(input<19>)
+    V(input<20>)
+    V(input<21>)
+    V(input<22>)
+    V(input<23>)
+    V(input<24>)
+    V(input<25>)
+    V(input<26>)
+    V(input<27>)
+    V(input<28>)
+    V(input<29>)
+    V(input<30>)
+    V(input<31>)
+    V(input<32>)
+    V(input<33>)
+    V(input<34>)
+    V(input<35>)
+    V(input<36>)
+    V(input<37>)
+    V(input<38>)
.PROBE TRAN
+    V(input<39>)
+    V(input<40>)
+    V(input<41>)
+    V(input<42>)
+    V(input<43>)
+    V(input<44>)
+    V(input<45>)
+    V(input<46>)
+    V(input<47>)
+    V(input<48>)
+    V(input<49>)
+    V(input<50>)
+    V(input<51>)
+    V(input<52>)
+    V(input<53>)
+    V(input<54>)
+    V(input<55>)
+    V(input<56>)
+    V(input<57>)
+    V(input<58>)
+    V(input<59>)
+    V(input<60>)
+    V(input<61>)
+    V(input<62>)
+    V(input<63>)
+    V(input<64>)
+    V(input<65>)
+    V(input<66>)
+    V(input<67>)
+    V(input<68>)
+    V(input<69>)
+    V(input<70>)
.PROBE TRAN
+    V(input<71>)
+    V(input<72>)
+    V(input<73>)
+    V(input<74>)
+    V(input<75>)
+    V(input<76>)
+    V(input<77>)
+    V(input<78>)
+    V(input<79>)
+    V(input<80>)
+    V(input<81>)
+    V(input<82>)
+    V(input<83>)
+    V(input<84>)
+    V(input<85>)
+    V(input<86>)
+    V(input<87>)
+    V(input<88>)
+    V(input<89>)
+    V(input<90>)
+    V(input<91>)
+    V(input<92>)
+    V(input<93>)
+    V(input<94>)
+    V(input<95>)
+    V(input<96>)
+    V(input<97>)
+    V(input<98>)
+    V(input<99>)
+    V(input<100>)
+    V(input<101>)
+    V(input<102>)
.PROBE TRAN
+    V(input<103>)
+    V(input<104>)
+    V(input<105>)
+    V(input<106>)
+    V(input<107>)
+    V(input<108>)
+    V(input<109>)
+    V(input<110>)
+    V(input<111>)
+    V(input<112>)
+    V(input<113>)
+    V(input<114>)
+    V(input<115>)
+    V(input<116>)
+    V(input<117>)
+    V(input<118>)
+    V(input<119>)
+    V(input<120>)
+    V(input<121>)
+    V(input<122>)
+    V(input<123>)
+    V(input<124>)
+    V(input<125>)
+    V(input<126>)
+    V(input<127>)
+    V(input<128>)
+    V(input<129>)
+    V(input<130>)
+    V(input<131>)
+    V(input<132>)
+    V(input<133>)
+    V(input<134>)
.PROBE TRAN
+    V(input<135>)
+    V(input<136>)
+    V(input<137>)
+    V(input<138>)
+    V(input<139>)
+    V(input<140>)
+    V(input<141>)
+    V(input<142>)
+    V(input<143>)
+    V(input<144>)
+    V(input<145>)
+    V(input<146>)
+    V(input<147>)
+    V(input<148>)
+    V(input<149>)
+    V(input<150>)
+    V(input<151>)
+    V(input<152>)
+    V(input<153>)
+    V(input<154>)
+    V(input<155>)
+    V(input<156>)
+    V(input<157>)
+    V(input<158>)
+    V(input<159>)
+    V(input<160>)
+    V(input<161>)
+    V(input<162>)
+    V(input<163>)
+    V(input<164>)
+    V(input<165>)
+    V(input<166>)
.PROBE TRAN
+    V(input<167>)
+    V(input<168>)
+    V(input<169>)
+    V(input<170>)
+    V(input<171>)
+    V(input<172>)
+    V(input<173>)
+    V(input<174>)
+    V(input<175>)
+    V(input<176>)
+    V(input<177>)
+    V(input<178>)
+    V(input<179>)
+    V(input<180>)
+    V(input<181>)
+    V(input<182>)
+    V(input<183>)
+    V(input<184>)
+    V(input<185>)
+    V(input<186>)
+    V(input<187>)
+    V(input<188>)
+    V(input<189>)
+    V(input<190>)
+    V(input<191>)
+    V(input<192>)
+    V(input<193>)
+    V(input<194>)
+    V(input<195>)
+    V(input<196>)
+    V(input<197>)
+    V(input<198>)
.PROBE TRAN
+    V(input<199>)
+    V(input<200>)
+    V(input<201>)
+    V(input<202>)
+    V(input<203>)
+    V(input<204>)
+    V(input<205>)
+    V(input<206>)
+    V(input<207>)
+    V(input<208>)
+    V(input<209>)
+    V(input<210>)
+    V(input<211>)
+    V(input<212>)
+    V(input<213>)
+    V(input<214>)
+    V(input<215>)
+    V(input<216>)
+    V(input<217>)
+    V(input<218>)
+    V(input<219>)
+    V(input<220>)
+    V(input<221>)
+    V(input<222>)
+    V(input<223>)
+    V(input<224>)
+    V(input<225>)
+    V(input<226>)
+    V(input<227>)
+    V(input<228>)
+    V(input<229>)
+    V(input<230>)
.PROBE TRAN
+    V(input<231>)
+    V(input<232>)
+    V(input<233>)
+    V(input<234>)
+    V(input<235>)
+    V(input<236>)
+    V(input<237>)
+    V(input<238>)
+    V(input<239>)
+    V(input<240>)
+    V(input<241>)
+    V(input<242>)
+    V(input<243>)
+    V(input<244>)
+    V(input<245>)
+    V(input<246>)
+    V(input<247>)
+    V(input<248>)
+    V(input<249>)
+    V(input<250>)
+    V(input<251>)
+    V(input<252>)
+    V(input<253>)
+    V(input<254>)
+    V(input<255>)
+    V(weight<0>)
+    V(weight<1>)
+    V(weight<2>)
+    V(weight<3>)
+    V(weight<4>)
+    V(weight<5>)
+    V(weight<6>)
.PROBE TRAN
+    V(weight<7>)
+    V(weight<8>)
+    V(weight<9>)
+    V(weight<10>)
+    V(weight<11>)
+    V(weight<12>)
+    V(weight<13>)
+    V(weight<14>)
+    V(weight<15>)
+    V(weight<16>)
+    V(weight<17>)
+    V(weight<18>)
+    V(weight<19>)
+    V(weight<20>)
+    V(weight<21>)
+    V(weight<22>)
+    V(weight<23>)
+    V(weight<24>)
+    V(weight<25>)
+    V(weight<26>)
+    V(weight<27>)
+    V(weight<28>)
+    V(weight<29>)
+    V(weight<30>)
+    V(weight<31>)
+    V(weight<32>)
+    V(weight<33>)
+    V(weight<34>)
+    V(weight<35>)
+    V(weight<36>)
+    V(weight<37>)
+    V(weight<38>)
.PROBE TRAN
+    V(weight<39>)
+    V(weight<40>)
+    V(weight<41>)
+    V(weight<42>)
+    V(weight<43>)
+    V(weight<44>)
+    V(weight<45>)
+    V(weight<46>)
+    V(weight<47>)
+    V(weight<48>)
+    V(weight<49>)
+    V(weight<50>)
+    V(weight<51>)
+    V(weight<52>)
+    V(weight<53>)
+    V(weight<54>)
+    V(weight<55>)
+    V(weight<56>)
+    V(weight<57>)
+    V(weight<58>)
+    V(weight<59>)
+    V(weight<60>)
+    V(weight<61>)
+    V(weight<62>)
+    V(weight<63>)
+    V(weight<64>)
+    V(weight<65>)
+    V(weight<66>)
+    V(weight<67>)
+    V(weight<68>)
+    V(weight<69>)
+    V(weight<70>)
.PROBE TRAN
+    V(weight<71>)
+    V(weight<72>)
+    V(weight<73>)
+    V(weight<74>)
+    V(weight<75>)
+    V(weight<76>)
+    V(weight<77>)
+    V(weight<78>)
+    V(weight<79>)
+    V(weight<80>)
+    V(weight<81>)
+    V(weight<82>)
+    V(weight<83>)
+    V(weight<84>)
+    V(weight<85>)
+    V(weight<86>)
+    V(weight<87>)
+    V(weight<88>)
+    V(weight<89>)
+    V(weight<90>)
+    V(weight<91>)
+    V(weight<92>)
+    V(weight<93>)
+    V(weight<94>)
+    V(weight<95>)
+    V(weight<96>)
+    V(weight<97>)
+    V(weight<98>)
+    V(weight<99>)
+    V(weight<100>)
+    V(weight<101>)
+    V(weight<102>)
.PROBE TRAN
+    V(weight<103>)
+    V(weight<104>)
+    V(weight<105>)
+    V(weight<106>)
+    V(weight<107>)
+    V(weight<108>)
+    V(weight<109>)
+    V(weight<110>)
+    V(weight<111>)
+    V(weight<112>)
+    V(weight<113>)
+    V(weight<114>)
+    V(weight<115>)
+    V(weight<116>)
+    V(weight<117>)
+    V(weight<118>)
+    V(weight<119>)
+    V(weight<120>)
+    V(weight<121>)
+    V(weight<122>)
+    V(weight<123>)
+    V(weight<124>)
+    V(weight<125>)
+    V(weight<126>)
+    V(weight<127>)
+    V(weight<128>)
+    V(weight<129>)
+    V(weight<130>)
+    V(weight<131>)
+    V(weight<132>)
+    V(weight<133>)
+    V(weight<134>)
.PROBE TRAN
+    V(weight<135>)
+    V(weight<136>)
+    V(weight<137>)
+    V(weight<138>)
+    V(weight<139>)
+    V(weight<140>)
+    V(weight<141>)
+    V(weight<142>)
+    V(weight<143>)
+    V(weight<144>)
+    V(weight<145>)
+    V(weight<146>)
+    V(weight<147>)
+    V(weight<148>)
+    V(weight<149>)
+    V(weight<150>)
+    V(weight<151>)
+    V(weight<152>)
+    V(weight<153>)
+    V(weight<154>)
+    V(weight<155>)
+    V(weight<156>)
+    V(weight<157>)
+    V(weight<158>)
+    V(weight<159>)
+    V(weight<160>)
+    V(weight<161>)
+    V(weight<162>)
+    V(weight<163>)
+    V(weight<164>)
+    V(weight<165>)
+    V(weight<166>)
.PROBE TRAN
+    V(weight<167>)
+    V(weight<168>)
+    V(weight<169>)
+    V(weight<170>)
+    V(weight<171>)
+    V(weight<172>)
+    V(weight<173>)
+    V(weight<174>)
+    V(weight<175>)
+    V(weight<176>)
+    V(weight<177>)
+    V(weight<178>)
+    V(weight<179>)
+    V(weight<180>)
+    V(weight<181>)
+    V(weight<182>)
+    V(weight<183>)
+    V(weight<184>)
+    V(weight<185>)
+    V(weight<186>)
+    V(weight<187>)
+    V(weight<188>)
+    V(weight<189>)
+    V(weight<190>)
+    V(weight<191>)
+    V(weight_addr<0>)
+    V(weight_addr<1>)
+    V(weight_addr<2>)
+    V(weight_addr<3>)
+    V(weight_addr<4>)
+    V(result<0>)
+    V(result<1>)
.PROBE TRAN
+    V(result<2>)
+    V(result<3>)
+    V(result<4>)
+    V(result<5>)
+    V(result<6>)
+    V(result<7>)
+    V(result<8>)
+    V(result<9>)
+    V(result<10>)
+    V(result<11>)
+    V(result<12>)
+    V(result<13>)
+    V(result<14>)
+    V(result<15>)
+    V(result<16>)
+    V(result<17>)
+    V(result<18>)
+    V(result<19>)
+    V(result<20>)
+    V(result<21>)
+    V(result<22>)
+    V(result<23>)
+    V(result<24>)
+    V(result<25>)
+    V(result<26>)
+    V(result<27>)
+    V(result<28>)
+    V(result<29>)
+    V(result<30>)
+    V(result<31>)
+    V(result<32>)
+    V(result<33>)
.PROBE TRAN
+    V(result<34>)
+    V(result<35>)
+    V(result<36>)
+    V(result<37>)
+    V(result<38>)
+    V(result<39>)
+    V(result<40>)
+    V(result<41>)
+    V(result<42>)
+    V(result<43>)
+    V(result<44>)
+    V(result<45>)
+    V(result<46>)
+    V(result<47>)
+    V(result<48>)
+    V(result<49>)
+    V(result<50>)
+    V(result<51>)
+    V(result<52>)
+    V(result<53>)
+    V(result<54>)
+    V(result<55>)
+    V(result<56>)
+    V(result<57>)
+    V(result<58>)
+    V(result<59>)
+    V(result<60>)
+    V(result<61>)
+    V(result<62>)
+    V(result<63>)
+    V(result<64>)
+    V(result<65>)
.PROBE TRAN
+    V(result<66>)
+    V(result<67>)
+    V(result<68>)
+    V(result<69>)
+    V(result<70>)
+    V(result<71>)
+    V(result<72>)
+    V(result<73>)
+    V(result<74>)
+    V(result<75>)
+    V(result<76>)
+    V(result<77>)
+    V(result<78>)
+    V(result<79>)
+    V(result<80>)
+    V(result<81>)
+    V(result<82>)
+    V(result<83>)
+    V(result<84>)
+    V(result<85>)
+    V(result<86>)
+    V(result<87>)
+    V(result<88>)
+    V(result<89>)
+    V(result<90>)
+    V(result<91>)
+    V(result<92>)
+    V(result<93>)
+    V(result<94>)
+    V(result<95>)
+    V(result<96>)
+    V(result<97>)
.PROBE TRAN
+    V(result<98>)
+    V(result<99>)
+    V(result<100>)
+    V(result<101>)
+    V(result<102>)
+    V(result<103>)
+    V(result<104>)
+    V(result<105>)
+    V(result<106>)
+    V(result<107>)
+    V(result<108>)
+    V(result<109>)
+    V(result<110>)
+    V(result<111>)
+    V(result<112>)
+    V(result<113>)
+    V(result<114>)
+    V(result<115>)
+    V(result<116>)
+    V(result<117>)
+    V(result<118>)
+    V(result<119>)
+    V(result<120>)
+    V(result<121>)
+    V(result<122>)
+    V(result<123>)
+    V(result<124>)
+    V(result<125>)
+    V(result<126>)
+    V(result<127>)
+    V(result<128>)
+    V(result<129>)
.PROBE TRAN
+    V(result<130>)
+    V(result<131>)
+    V(result<132>)
+    V(result<133>)
+    V(result<134>)
+    V(result<135>)
+    V(result<136>)
+    V(result<137>)
+    V(result<138>)
+    V(result<139>)
+    V(result<140>)
+    V(result<141>)
+    V(result<142>)
+    V(result<143>)
+    V(result<144>)
+    V(result<145>)
+    V(result<146>)
+    V(result<147>)
+    V(result<148>)
+    V(result<149>)
+    V(result<150>)
+    V(result<151>)
+    V(result<152>)
+    V(result<153>)
+    V(result<154>)
+    V(result<155>)
+    V(result<156>)
+    V(result<157>)
+    V(result<158>)
+    V(result<159>)
+    V(result<160>)
+    V(result<161>)
.PROBE TRAN
+    V(result<162>)
+    V(result<163>)
+    V(result<164>)
+    V(result<165>)
+    V(result<166>)
+    V(result<167>)
+    V(result<168>)
+    V(result<169>)
+    V(result<170>)
+    V(result<171>)
+    V(result<172>)
+    V(result<173>)
+    V(result<174>)
+    V(result<175>)
+    V(result<176>)
+    V(result<177>)
+    V(result<178>)
+    V(result<179>)
+    V(result<180>)
+    V(result<181>)
+    V(result<182>)
+    V(result<183>)
+    V(result<184>)
+    V(result<185>)
+    V(result<186>)
+    V(result<187>)
+    V(result<188>)
+    V(result<189>)
+    V(result<190>)
+    V(result<191>)
+    V(result<192>)
+    V(result<193>)
.PROBE TRAN
+    V(result<194>)
+    V(result<195>)
+    V(result<196>)
+    V(result<197>)
+    V(result<198>)
+    V(result<199>)
+    V(result<200>)
+    V(result<201>)
+    V(result<202>)
+    V(result<203>)
+    V(result<204>)
+    V(result<205>)
+    V(result<206>)
+    V(result<207>)
+    V(result<208>)
+    V(result<209>)
+    V(result<210>)
+    V(result<211>)
+    V(result<212>)
+    V(result<213>)
+    V(result<214>)
+    V(result<215>)
+    V(result<216>)
+    V(result<217>)
+    V(result<218>)
+    V(result<219>)
+    V(result<220>)
+    V(result<221>)
+    V(result<222>)
+    V(result<223>)
+    V(result<224>)
+    V(result<225>)
.PROBE TRAN
+    V(result<226>)
+    V(result<227>)
+    V(result<228>)
+    V(result<229>)
+    V(result<230>)
+    V(result<231>)
+    V(result<232>)
+    V(result<233>)
+    V(result<234>)
+    V(result<235>)
+    V(result<236>)
+    V(result<237>)
+    V(result<238>)
+    V(result<239>)
+    V(result<240>)
+    V(result<241>)
+    V(result<242>)
+    V(result<243>)
+    V(result<244>)
+    V(result<245>)
+    V(result<246>)
+    V(result<247>)
+    V(result<248>)
+    V(result<249>)
+    V(result<250>)
+    V(result<251>)
+    V(result<252>)
+    V(result<253>)
+    V(result<254>)
+    V(result<255>)
