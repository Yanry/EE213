.subckt xrom_weight_inv a z s=1
m1 z a vdd! vdd! PMOS_VTL L=50e-9 W='s*180e-9'
m0 z a 0 0 NMOS_VTL L=50e-9 W='s*90e-9'
.ends

.subckt xrom_weight_and a b out s=1
m1 net16 a 0 0 NMOS_VTL L=50e-9 W='s*90e-9'
m0 z b net16 0 NMOS_VTL L=50e-9 W='s*90e-9'
m3 z b vdd! vdd! PMOS_VTL L=50e-9 W='s*90e-9'
m4 z a vdd! vdd! PMOS_VTL L=50e-9 W='s*90e-9'
xinv z out xrom_weight_inv
.ends

.subckt xrom_weight_and_tree a<0> a<1> a<2> a<3> a<4> out
xrom_and0 and0_left_in and0_right_in out xrom_weight_and s=1
xrom_and1 a<0> a<1> and0_left_in xrom_weight_and s=1
xrom_and2 and2_left_in and2_right_in and0_right_in xrom_weight_and s=1
v_and2_left_in and2_left_in a<2> DC=0
xrom_and3 a<3> a<4> and2_right_in xrom_weight_and s=1
.ends

.subckt xrom_weight_dec a<0> a<1> a<2> a<3> a<4> q<0> q<1> q<2> q<3> q<4> q<5> q<6> q<7> q<8> q<9> q<10>
+ q<11> q<12> q<13> q<14> q<15> q<16> q<17> q<18> q<19> q<20> q<21> q<22> q<23> q<24> q<25> q<26>
+ q<27> q<28> q<29> q<30> q<31>
xrom_inv0 a<0> a_inv<0> xrom_weight_inv s=2
xrom_inv1 a<1> a_inv<1> xrom_weight_inv s=2
xrom_inv2 a<2> a_inv<2> xrom_weight_inv s=2
xrom_inv3 a<3> a_inv<3> xrom_weight_inv s=2
xrom_inv4 a<4> a_inv<4> xrom_weight_inv s=2
xrom_and_tree0 a_inv<0> a_inv<1> a_inv<2> a_inv<3> a_inv<4> q<0> xrom_weight_and_tree
xrom_and_tree1 a<0> a_inv<1> a_inv<2> a_inv<3> a_inv<4> q<1> xrom_weight_and_tree
xrom_and_tree2 a_inv<0> a<1> a_inv<2> a_inv<3> a_inv<4> q<2> xrom_weight_and_tree
xrom_and_tree3 a<0> a<1> a_inv<2> a_inv<3> a_inv<4> q<3> xrom_weight_and_tree
xrom_and_tree4 a_inv<0> a_inv<1> a<2> a_inv<3> a_inv<4> q<4> xrom_weight_and_tree
xrom_and_tree5 a<0> a_inv<1> a<2> a_inv<3> a_inv<4> q<5> xrom_weight_and_tree
xrom_and_tree6 a_inv<0> a<1> a<2> a_inv<3> a_inv<4> q<6> xrom_weight_and_tree
xrom_and_tree7 a<0> a<1> a<2> a_inv<3> a_inv<4> q<7> xrom_weight_and_tree
xrom_and_tree8 a_inv<0> a_inv<1> a_inv<2> a<3> a_inv<4> q<8> xrom_weight_and_tree
xrom_and_tree9 a<0> a_inv<1> a_inv<2> a<3> a_inv<4> q<9> xrom_weight_and_tree
xrom_and_tree10 a_inv<0> a<1> a_inv<2> a<3> a_inv<4> q<10> xrom_weight_and_tree
xrom_and_tree11 a<0> a<1> a_inv<2> a<3> a_inv<4> q<11> xrom_weight_and_tree
xrom_and_tree12 a_inv<0> a_inv<1> a<2> a<3> a_inv<4> q<12> xrom_weight_and_tree
xrom_and_tree13 a<0> a_inv<1> a<2> a<3> a_inv<4> q<13> xrom_weight_and_tree
xrom_and_tree14 a_inv<0> a<1> a<2> a<3> a_inv<4> q<14> xrom_weight_and_tree
xrom_and_tree15 a<0> a<1> a<2> a<3> a_inv<4> q<15> xrom_weight_and_tree
xrom_and_tree16 a_inv<0> a_inv<1> a_inv<2> a_inv<3> a<4> q<16> xrom_weight_and_tree
xrom_and_tree17 a<0> a_inv<1> a_inv<2> a_inv<3> a<4> q<17> xrom_weight_and_tree
xrom_and_tree18 a_inv<0> a<1> a_inv<2> a_inv<3> a<4> q<18> xrom_weight_and_tree
xrom_and_tree19 a<0> a<1> a_inv<2> a_inv<3> a<4> q<19> xrom_weight_and_tree
xrom_and_tree20 a_inv<0> a_inv<1> a<2> a_inv<3> a<4> q<20> xrom_weight_and_tree
xrom_and_tree21 a<0> a_inv<1> a<2> a_inv<3> a<4> q<21> xrom_weight_and_tree
xrom_and_tree22 a_inv<0> a<1> a<2> a_inv<3> a<4> q<22> xrom_weight_and_tree
xrom_and_tree23 a<0> a<1> a<2> a_inv<3> a<4> q<23> xrom_weight_and_tree
xrom_and_tree24 a_inv<0> a_inv<1> a_inv<2> a<3> a<4> q<24> xrom_weight_and_tree
xrom_and_tree25 a<0> a_inv<1> a_inv<2> a<3> a<4> q<25> xrom_weight_and_tree
xrom_and_tree26 a_inv<0> a<1> a_inv<2> a<3> a<4> q<26> xrom_weight_and_tree
xrom_and_tree27 a<0> a<1> a_inv<2> a<3> a<4> q<27> xrom_weight_and_tree
xrom_and_tree28 a_inv<0> a_inv<1> a<2> a<3> a<4> q<28> xrom_weight_and_tree
xrom_and_tree29 a<0> a_inv<1> a<2> a<3> a<4> q<29> xrom_weight_and_tree
xrom_and_tree30 a_inv<0> a<1> a<2> a<3> a<4> q<30> xrom_weight_and_tree
xrom_and_tree31 a<0> a<1> a<2> a<3> a<4> q<31> xrom_weight_and_tree
.ends

.subckt xrom_weight_array sel<0> sel<1> sel<2> sel<3> sel<4> sel<5> sel<6> sel<7> sel<8> sel<9> sel<10> sel<11> sel<12> sel<13> sel<14> sel<15>
+ sel<16> sel<17> sel<18> sel<19> sel<20> sel<21> sel<22> sel<23> sel<24> sel<25> sel<26> sel<27> sel<28> sel<29> sel<30> sel<31>
+ out<0> out<1> out<2> out<3> out<4> out<5> out<6> out<7> out<8> out<9> out<10> out<11> out<12> out<13> out<14> out<15>
+ out<16> out<17> out<18> out<19> out<20> out<21> out<22> out<23> out<24> out<25> out<26> out<27> out<28> out<29> out<30> out<31>
+ out<32> out<33> out<34> out<35> out<36> out<37> out<38> out<39> out<40> out<41> out<42> out<43> out<44> out<45> out<46> out<47>
+ out<48> out<49> out<50> out<51> out<52> out<53> out<54> out<55> out<56> out<57> out<58> out<59> out<60> out<61> out<62> out<63>
+ out<64> out<65> out<66> out<67> out<68> out<69> out<70> out<71> out<72> out<73> out<74> out<75> out<76> out<77> out<78> out<79>
+ out<80> out<81> out<82> out<83> out<84> out<85> out<86> out<87> out<88> out<89> out<90> out<91> out<92> out<93> out<94> out<95>
+ out<96> out<97> out<98> out<99> out<100> out<101> out<102> out<103> out<104> out<105> out<106> out<107> out<108> out<109> out<110> out<111>
+ out<112> out<113> out<114> out<115> out<116> out<117> out<118> out<119> out<120> out<121> out<122> out<123> out<124> out<125> out<126> out<127>
+ out<128> out<129> out<130> out<131> out<132> out<133> out<134> out<135> out<136> out<137> out<138> out<139> out<140> out<141> out<142> out<143>
+ out<144> out<145> out<146> out<147> out<148> out<149> out<150> out<151> out<152> out<153> out<154> out<155> out<156> out<157> out<158> out<159>
+ out<160> out<161> out<162> out<163> out<164> out<165> out<166> out<167> out<168> out<169> out<170> out<171> out<172> out<173> out<174> out<175>
+ out<176> out<177> out<178> out<179> out<180> out<181> out<182> out<183> out<184> out<185> out<186> out<187> out<188> out<189> out<190> out<191>
R0 vdd! col<0> 310000
R1 vdd! col<1> 310000
R2 vdd! col<2> 310000
R3 vdd! col<3> 310000
R4 vdd! col<4> 310000
R5 vdd! col<5> 310000
R6 vdd! col<6> 310000
R7 vdd! col<7> 310000
R8 vdd! col<8> 310000
R9 vdd! col<9> 310000
R10 vdd! col<10> 310000
R11 vdd! col<11> 310000
R12 vdd! col<12> 310000
R13 vdd! col<13> 310000
R14 vdd! col<14> 310000
R15 vdd! col<15> 310000
R16 vdd! col<16> 310000
R17 vdd! col<17> 310000
R18 vdd! col<18> 310000
R19 vdd! col<19> 310000
R20 vdd! col<20> 310000
R21 vdd! col<21> 310000
R22 vdd! col<22> 310000
R23 vdd! col<23> 310000
R24 vdd! col<24> 310000
R25 vdd! col<25> 310000
R26 vdd! col<26> 310000
R27 vdd! col<27> 310000
R28 vdd! col<28> 310000
R29 vdd! col<29> 310000
R30 vdd! col<30> 310000
R31 vdd! col<31> 310000
R32 vdd! col<32> 310000
R33 vdd! col<33> 310000
R34 vdd! col<34> 310000
R35 vdd! col<35> 310000
R36 vdd! col<36> 310000
R37 vdd! col<37> 310000
R38 vdd! col<38> 310000
R39 vdd! col<39> 310000
R40 vdd! col<40> 310000
R41 vdd! col<41> 310000
R42 vdd! col<42> 310000
R43 vdd! col<43> 310000
R44 vdd! col<44> 310000
R45 vdd! col<45> 310000
R46 vdd! col<46> 310000
R47 vdd! col<47> 310000
R48 vdd! col<48> 310000
R49 vdd! col<49> 310000
R50 vdd! col<50> 310000
R51 vdd! col<51> 310000
R52 vdd! col<52> 310000
R53 vdd! col<53> 310000
R54 vdd! col<54> 310000
R55 vdd! col<55> 310000
R56 vdd! col<56> 310000
R57 vdd! col<57> 310000
R58 vdd! col<58> 310000
R59 vdd! col<59> 310000
R60 vdd! col<60> 310000
R61 vdd! col<61> 310000
R62 vdd! col<62> 310000
R63 vdd! col<63> 310000
R64 vdd! col<64> 310000
R65 vdd! col<65> 310000
R66 vdd! col<66> 310000
R67 vdd! col<67> 310000
R68 vdd! col<68> 310000
R69 vdd! col<69> 310000
R70 vdd! col<70> 310000
R71 vdd! col<71> 310000
R72 vdd! col<72> 310000
R73 vdd! col<73> 310000
R74 vdd! col<74> 310000
R75 vdd! col<75> 310000
R76 vdd! col<76> 310000
R77 vdd! col<77> 310000
R78 vdd! col<78> 310000
R79 vdd! col<79> 310000
R80 vdd! col<80> 310000
R81 vdd! col<81> 310000
R82 vdd! col<82> 310000
R83 vdd! col<83> 310000
R84 vdd! col<84> 310000
R85 vdd! col<85> 310000
R86 vdd! col<86> 310000
R87 vdd! col<87> 310000
R88 vdd! col<88> 310000
R89 vdd! col<89> 310000
R90 vdd! col<90> 310000
R91 vdd! col<91> 310000
R92 vdd! col<92> 310000
R93 vdd! col<93> 310000
R94 vdd! col<94> 310000
R95 vdd! col<95> 310000
R96 vdd! col<96> 310000
R97 vdd! col<97> 310000
R98 vdd! col<98> 310000
R99 vdd! col<99> 310000
R100 vdd! col<100> 310000
R101 vdd! col<101> 310000
R102 vdd! col<102> 310000
R103 vdd! col<103> 310000
R104 vdd! col<104> 310000
R105 vdd! col<105> 310000
R106 vdd! col<106> 310000
R107 vdd! col<107> 310000
R108 vdd! col<108> 310000
R109 vdd! col<109> 310000
R110 vdd! col<110> 310000
R111 vdd! col<111> 310000
R112 vdd! col<112> 310000
R113 vdd! col<113> 310000
R114 vdd! col<114> 310000
R115 vdd! col<115> 310000
R116 vdd! col<116> 310000
R117 vdd! col<117> 310000
R118 vdd! col<118> 310000
R119 vdd! col<119> 310000
R120 vdd! col<120> 310000
R121 vdd! col<121> 310000
R122 vdd! col<122> 310000
R123 vdd! col<123> 310000
R124 vdd! col<124> 310000
R125 vdd! col<125> 310000
R126 vdd! col<126> 310000
R127 vdd! col<127> 310000
R128 vdd! col<128> 310000
R129 vdd! col<129> 310000
R130 vdd! col<130> 310000
R131 vdd! col<131> 310000
R132 vdd! col<132> 310000
R133 vdd! col<133> 310000
R134 vdd! col<134> 310000
R135 vdd! col<135> 310000
R136 vdd! col<136> 310000
R137 vdd! col<137> 310000
R138 vdd! col<138> 310000
R139 vdd! col<139> 310000
R140 vdd! col<140> 310000
R141 vdd! col<141> 310000
R142 vdd! col<142> 310000
R143 vdd! col<143> 310000
R144 vdd! col<144> 310000
R145 vdd! col<145> 310000
R146 vdd! col<146> 310000
R147 vdd! col<147> 310000
R148 vdd! col<148> 310000
R149 vdd! col<149> 310000
R150 vdd! col<150> 310000
R151 vdd! col<151> 310000
R152 vdd! col<152> 310000
R153 vdd! col<153> 310000
R154 vdd! col<154> 310000
R155 vdd! col<155> 310000
R156 vdd! col<156> 310000
R157 vdd! col<157> 310000
R158 vdd! col<158> 310000
R159 vdd! col<159> 310000
R160 vdd! col<160> 310000
R161 vdd! col<161> 310000
R162 vdd! col<162> 310000
R163 vdd! col<163> 310000
R164 vdd! col<164> 310000
R165 vdd! col<165> 310000
R166 vdd! col<166> 310000
R167 vdd! col<167> 310000
R168 vdd! col<168> 310000
R169 vdd! col<169> 310000
R170 vdd! col<170> 310000
R171 vdd! col<171> 310000
R172 vdd! col<172> 310000
R173 vdd! col<173> 310000
R174 vdd! col<174> 310000
R175 vdd! col<175> 310000
R176 vdd! col<176> 310000
R177 vdd! col<177> 310000
R178 vdd! col<178> 310000
R179 vdd! col<179> 310000
R180 vdd! col<180> 310000
R181 vdd! col<181> 310000
R182 vdd! col<182> 310000
R183 vdd! col<183> 310000
R184 vdd! col<184> 310000
R185 vdd! col<185> 310000
R186 vdd! col<186> 310000
R187 vdd! col<187> 310000
R188 vdd! col<188> 310000
R189 vdd! col<189> 310000
R190 vdd! col<190> 310000
R191 vdd! col<191> 310000
mn0 col<0> sel<0> 0 0 NMOS_VTL L=50e-9 W='1*90e-9'
mn1 col<1> sel<0> 0 0 NMOS_VTL L=50e-9 W='1*90e-9'
mn2 col<2> sel<0> 0 0 NMOS_VTL L=50e-9 W='1*90e-9'
mn9 col<9> sel<0> 0 0 NMOS_VTL L=50e-9 W='1*90e-9'
mn10 col<10> sel<0> 0 0 NMOS_VTL L=50e-9 W='1*90e-9'
mn11 col<11> sel<0> 0 0 NMOS_VTL L=50e-9 W='1*90e-9'
mn12 col<12> sel<0> 0 0 NMOS_VTL L=50e-9 W='1*90e-9'
mn13 col<13> sel<0> 0 0 NMOS_VTL L=50e-9 W='1*90e-9'
mn14 col<14> sel<0> 0 0 NMOS_VTL L=50e-9 W='1*90e-9'
mn15 col<15> sel<0> 0 0 NMOS_VTL L=50e-9 W='1*90e-9'
mn16 col<16> sel<0> 0 0 NMOS_VTL L=50e-9 W='1*90e-9'
mn17 col<17> sel<0> 0 0 NMOS_VTL L=50e-9 W='1*90e-9'
mn18 col<18> sel<0> 0 0 NMOS_VTL L=50e-9 W='1*90e-9'
mn19 col<19> sel<0> 0 0 NMOS_VTL L=50e-9 W='1*90e-9'
mn20 col<20> sel<0> 0 0 NMOS_VTL L=50e-9 W='1*90e-9'
mn30 col<30> sel<0> 0 0 NMOS_VTL L=50e-9 W='1*90e-9'
mn31 col<31> sel<0> 0 0 NMOS_VTL L=50e-9 W='1*90e-9'
mn32 col<32> sel<0> 0 0 NMOS_VTL L=50e-9 W='1*90e-9'
mn36 col<36> sel<0> 0 0 NMOS_VTL L=50e-9 W='1*90e-9'
mn37 col<37> sel<0> 0 0 NMOS_VTL L=50e-9 W='1*90e-9'
mn38 col<38> sel<0> 0 0 NMOS_VTL L=50e-9 W='1*90e-9'
mn42 col<42> sel<0> 0 0 NMOS_VTL L=50e-9 W='1*90e-9'
mn43 col<43> sel<0> 0 0 NMOS_VTL L=50e-9 W='1*90e-9'
mn44 col<44> sel<0> 0 0 NMOS_VTL L=50e-9 W='1*90e-9'
mn45 col<45> sel<0> 0 0 NMOS_VTL L=50e-9 W='1*90e-9'
mn46 col<46> sel<0> 0 0 NMOS_VTL L=50e-9 W='1*90e-9'
mn47 col<47> sel<0> 0 0 NMOS_VTL L=50e-9 W='1*90e-9'
mn51 col<51> sel<0> 0 0 NMOS_VTL L=50e-9 W='1*90e-9'
mn52 col<52> sel<0> 0 0 NMOS_VTL L=50e-9 W='1*90e-9'
mn53 col<53> sel<0> 0 0 NMOS_VTL L=50e-9 W='1*90e-9'
mn72 col<72> sel<0> 0 0 NMOS_VTL L=50e-9 W='1*90e-9'
mn73 col<73> sel<0> 0 0 NMOS_VTL L=50e-9 W='1*90e-9'
mn74 col<74> sel<0> 0 0 NMOS_VTL L=50e-9 W='1*90e-9'
mn75 col<75> sel<0> 0 0 NMOS_VTL L=50e-9 W='1*90e-9'
mn76 col<76> sel<0> 0 0 NMOS_VTL L=50e-9 W='1*90e-9'
mn77 col<77> sel<0> 0 0 NMOS_VTL L=50e-9 W='1*90e-9'
mn79 col<79> sel<0> 0 0 NMOS_VTL L=50e-9 W='1*90e-9'
mn80 col<80> sel<0> 0 0 NMOS_VTL L=50e-9 W='1*90e-9'
mn82 col<82> sel<0> 0 0 NMOS_VTL L=50e-9 W='1*90e-9'
mn83 col<83> sel<0> 0 0 NMOS_VTL L=50e-9 W='1*90e-9'
mn87 col<87> sel<0> 0 0 NMOS_VTL L=50e-9 W='1*90e-9'
mn88 col<88> sel<0> 0 0 NMOS_VTL L=50e-9 W='1*90e-9'
mn89 col<89> sel<0> 0 0 NMOS_VTL L=50e-9 W='1*90e-9'
mn93 col<93> sel<0> 0 0 NMOS_VTL L=50e-9 W='1*90e-9'
mn94 col<94> sel<0> 0 0 NMOS_VTL L=50e-9 W='1*90e-9'
mn95 col<95> sel<0> 0 0 NMOS_VTL L=50e-9 W='1*90e-9'
mn99 col<99> sel<0> 0 0 NMOS_VTL L=50e-9 W='1*90e-9'
mn100 col<100> sel<0> 0 0 NMOS_VTL L=50e-9 W='1*90e-9'
mn101 col<101> sel<0> 0 0 NMOS_VTL L=50e-9 W='1*90e-9'
mn102 col<102> sel<0> 0 0 NMOS_VTL L=50e-9 W='1*90e-9'
mn103 col<103> sel<0> 0 0 NMOS_VTL L=50e-9 W='1*90e-9'
mn104 col<104> sel<0> 0 0 NMOS_VTL L=50e-9 W='1*90e-9'
mn105 col<105> sel<0> 0 0 NMOS_VTL L=50e-9 W='1*90e-9'
mn106 col<106> sel<0> 0 0 NMOS_VTL L=50e-9 W='1*90e-9'
mn107 col<107> sel<0> 0 0 NMOS_VTL L=50e-9 W='1*90e-9'
mn111 col<111> sel<0> 0 0 NMOS_VTL L=50e-9 W='1*90e-9'
mn112 col<112> sel<0> 0 0 NMOS_VTL L=50e-9 W='1*90e-9'
mn113 col<113> sel<0> 0 0 NMOS_VTL L=50e-9 W='1*90e-9'
mn114 col<114> sel<0> 0 0 NMOS_VTL L=50e-9 W='1*90e-9'
mn115 col<115> sel<0> 0 0 NMOS_VTL L=50e-9 W='1*90e-9'
mn116 col<116> sel<0> 0 0 NMOS_VTL L=50e-9 W='1*90e-9'
mn117 col<117> sel<0> 0 0 NMOS_VTL L=50e-9 W='1*90e-9'
mn118 col<118> sel<0> 0 0 NMOS_VTL L=50e-9 W='1*90e-9'
mn119 col<119> sel<0> 0 0 NMOS_VTL L=50e-9 W='1*90e-9'
mn123 col<123> sel<0> 0 0 NMOS_VTL L=50e-9 W='1*90e-9'
mn124 col<124> sel<0> 0 0 NMOS_VTL L=50e-9 W='1*90e-9'
mn125 col<125> sel<0> 0 0 NMOS_VTL L=50e-9 W='1*90e-9'
mn132 col<132> sel<0> 0 0 NMOS_VTL L=50e-9 W='1*90e-9'
mn133 col<133> sel<0> 0 0 NMOS_VTL L=50e-9 W='1*90e-9'
mn134 col<134> sel<0> 0 0 NMOS_VTL L=50e-9 W='1*90e-9'
mn135 col<135> sel<0> 0 0 NMOS_VTL L=50e-9 W='1*90e-9'
mn136 col<136> sel<0> 0 0 NMOS_VTL L=50e-9 W='1*90e-9'
mn137 col<137> sel<0> 0 0 NMOS_VTL L=50e-9 W='1*90e-9'
mn138 col<138> sel<0> 0 0 NMOS_VTL L=50e-9 W='1*90e-9'
mn139 col<139> sel<0> 0 0 NMOS_VTL L=50e-9 W='1*90e-9'
mn140 col<140> sel<0> 0 0 NMOS_VTL L=50e-9 W='1*90e-9'
mn141 col<141> sel<0> 0 0 NMOS_VTL L=50e-9 W='1*90e-9'
mn142 col<142> sel<0> 0 0 NMOS_VTL L=50e-9 W='1*90e-9'
mn143 col<143> sel<0> 0 0 NMOS_VTL L=50e-9 W='1*90e-9'
mn147 col<147> sel<0> 0 0 NMOS_VTL L=50e-9 W='1*90e-9'
mn148 col<148> sel<0> 0 0 NMOS_VTL L=50e-9 W='1*90e-9'
mn149 col<149> sel<0> 0 0 NMOS_VTL L=50e-9 W='1*90e-9'
mn153 col<153> sel<0> 0 0 NMOS_VTL L=50e-9 W='1*90e-9'
mn154 col<154> sel<0> 0 0 NMOS_VTL L=50e-9 W='1*90e-9'
mn155 col<155> sel<0> 0 0 NMOS_VTL L=50e-9 W='1*90e-9'
mn157 col<157> sel<0> 0 0 NMOS_VTL L=50e-9 W='1*90e-9'
mn158 col<158> sel<0> 0 0 NMOS_VTL L=50e-9 W='1*90e-9'
mn159 col<159> sel<0> 0 0 NMOS_VTL L=50e-9 W='1*90e-9'
mn160 col<160> sel<0> 0 0 NMOS_VTL L=50e-9 W='1*90e-9'
mn161 col<161> sel<0> 0 0 NMOS_VTL L=50e-9 W='1*90e-9'
mn162 col<162> sel<0> 0 0 NMOS_VTL L=50e-9 W='1*90e-9'
mn163 col<163> sel<0> 0 0 NMOS_VTL L=50e-9 W='1*90e-9'
mn164 col<164> sel<0> 0 0 NMOS_VTL L=50e-9 W='1*90e-9'
mn165 col<165> sel<0> 0 0 NMOS_VTL L=50e-9 W='1*90e-9'
mn166 col<166> sel<0> 0 0 NMOS_VTL L=50e-9 W='1*90e-9'
mn167 col<167> sel<0> 0 0 NMOS_VTL L=50e-9 W='1*90e-9'
mn171 col<171> sel<0> 0 0 NMOS_VTL L=50e-9 W='1*90e-9'
mn172 col<172> sel<0> 0 0 NMOS_VTL L=50e-9 W='1*90e-9'
mn173 col<173> sel<0> 0 0 NMOS_VTL L=50e-9 W='1*90e-9'
mn180 col<180> sel<0> 0 0 NMOS_VTL L=50e-9 W='1*90e-9'
mn181 col<181> sel<0> 0 0 NMOS_VTL L=50e-9 W='1*90e-9'
mn182 col<182> sel<0> 0 0 NMOS_VTL L=50e-9 W='1*90e-9'
mn183 col<183> sel<0> 0 0 NMOS_VTL L=50e-9 W='1*90e-9'
mn184 col<184> sel<0> 0 0 NMOS_VTL L=50e-9 W='1*90e-9'
mn185 col<185> sel<0> 0 0 NMOS_VTL L=50e-9 W='1*90e-9'
mn189 col<189> sel<0> 0 0 NMOS_VTL L=50e-9 W='1*90e-9'
mn190 col<190> sel<0> 0 0 NMOS_VTL L=50e-9 W='1*90e-9'
mn191 col<191> sel<0> 0 0 NMOS_VTL L=50e-9 W='1*90e-9'
mn195 col<3> sel<1> 0 0 NMOS_VTL L=50e-9 W='1*90e-9'
mn196 col<4> sel<1> 0 0 NMOS_VTL L=50e-9 W='1*90e-9'
mn197 col<5> sel<1> 0 0 NMOS_VTL L=50e-9 W='1*90e-9'
mn201 col<9> sel<1> 0 0 NMOS_VTL L=50e-9 W='1*90e-9'
mn202 col<10> sel<1> 0 0 NMOS_VTL L=50e-9 W='1*90e-9'
mn203 col<11> sel<1> 0 0 NMOS_VTL L=50e-9 W='1*90e-9'
mn207 col<15> sel<1> 0 0 NMOS_VTL L=50e-9 W='1*90e-9'
mn208 col<16> sel<1> 0 0 NMOS_VTL L=50e-9 W='1*90e-9'
mn209 col<17> sel<1> 0 0 NMOS_VTL L=50e-9 W='1*90e-9'
mn210 col<18> sel<1> 0 0 NMOS_VTL L=50e-9 W='1*90e-9'
mn211 col<19> sel<1> 0 0 NMOS_VTL L=50e-9 W='1*90e-9'
mn212 col<20> sel<1> 0 0 NMOS_VTL L=50e-9 W='1*90e-9'
mn213 col<21> sel<1> 0 0 NMOS_VTL L=50e-9 W='1*90e-9'
mn214 col<22> sel<1> 0 0 NMOS_VTL L=50e-9 W='1*90e-9'
mn215 col<23> sel<1> 0 0 NMOS_VTL L=50e-9 W='1*90e-9'
mn216 col<24> sel<1> 0 0 NMOS_VTL L=50e-9 W='1*90e-9'
mn217 col<25> sel<1> 0 0 NMOS_VTL L=50e-9 W='1*90e-9'
mn218 col<26> sel<1> 0 0 NMOS_VTL L=50e-9 W='1*90e-9'
mn219 col<27> sel<1> 0 0 NMOS_VTL L=50e-9 W='1*90e-9'
mn220 col<28> sel<1> 0 0 NMOS_VTL L=50e-9 W='1*90e-9'
mn221 col<29> sel<1> 0 0 NMOS_VTL L=50e-9 W='1*90e-9'
mn223 col<31> sel<1> 0 0 NMOS_VTL L=50e-9 W='1*90e-9'
mn224 col<32> sel<1> 0 0 NMOS_VTL L=50e-9 W='1*90e-9'
mn226 col<34> sel<1> 0 0 NMOS_VTL L=50e-9 W='1*90e-9'
mn227 col<35> sel<1> 0 0 NMOS_VTL L=50e-9 W='1*90e-9'
mn229 col<37> sel<1> 0 0 NMOS_VTL L=50e-9 W='1*90e-9'
mn230 col<38> sel<1> 0 0 NMOS_VTL L=50e-9 W='1*90e-9'
mn232 col<40> sel<1> 0 0 NMOS_VTL L=50e-9 W='1*90e-9'
mn233 col<41> sel<1> 0 0 NMOS_VTL L=50e-9 W='1*90e-9'
mn237 col<45> sel<1> 0 0 NMOS_VTL L=50e-9 W='1*90e-9'
mn238 col<46> sel<1> 0 0 NMOS_VTL L=50e-9 W='1*90e-9'
mn239 col<47> sel<1> 0 0 NMOS_VTL L=50e-9 W='1*90e-9'
mn240 col<48> sel<1> 0 0 NMOS_VTL L=50e-9 W='1*90e-9'
mn241 col<49> sel<1> 0 0 NMOS_VTL L=50e-9 W='1*90e-9'
mn242 col<50> sel<1> 0 0 NMOS_VTL L=50e-9 W='1*90e-9'
mn243 col<51> sel<1> 0 0 NMOS_VTL L=50e-9 W='1*90e-9'
mn244 col<52> sel<1> 0 0 NMOS_VTL L=50e-9 W='1*90e-9'
mn245 col<53> sel<1> 0 0 NMOS_VTL L=50e-9 W='1*90e-9'
mn247 col<55> sel<1> 0 0 NMOS_VTL L=50e-9 W='1*90e-9'
mn249 col<57> sel<1> 0 0 NMOS_VTL L=50e-9 W='1*90e-9'
mn250 col<58> sel<1> 0 0 NMOS_VTL L=50e-9 W='1*90e-9'
mn255 col<63> sel<1> 0 0 NMOS_VTL L=50e-9 W='1*90e-9'
mn264 col<72> sel<1> 0 0 NMOS_VTL L=50e-9 W='1*90e-9'
mn265 col<73> sel<1> 0 0 NMOS_VTL L=50e-9 W='1*90e-9'
mn266 col<74> sel<1> 0 0 NMOS_VTL L=50e-9 W='1*90e-9'
mn267 col<75> sel<1> 0 0 NMOS_VTL L=50e-9 W='1*90e-9'
mn270 col<78> sel<1> 0 0 NMOS_VTL L=50e-9 W='1*90e-9'
mn271 col<79> sel<1> 0 0 NMOS_VTL L=50e-9 W='1*90e-9'
mn276 col<84> sel<1> 0 0 NMOS_VTL L=50e-9 W='1*90e-9'
mn277 col<85> sel<1> 0 0 NMOS_VTL L=50e-9 W='1*90e-9'
mn278 col<86> sel<1> 0 0 NMOS_VTL L=50e-9 W='1*90e-9'
mn279 col<87> sel<1> 0 0 NMOS_VTL L=50e-9 W='1*90e-9'
mn280 col<88> sel<1> 0 0 NMOS_VTL L=50e-9 W='1*90e-9'
mn285 col<93> sel<1> 0 0 NMOS_VTL L=50e-9 W='1*90e-9'
mn286 col<94> sel<1> 0 0 NMOS_VTL L=50e-9 W='1*90e-9'
mn287 col<95> sel<1> 0 0 NMOS_VTL L=50e-9 W='1*90e-9'
mn288 col<96> sel<1> 0 0 NMOS_VTL L=50e-9 W='1*90e-9'
mn289 col<97> sel<1> 0 0 NMOS_VTL L=50e-9 W='1*90e-9'
mn290 col<98> sel<1> 0 0 NMOS_VTL L=50e-9 W='1*90e-9'
mn297 col<105> sel<1> 0 0 NMOS_VTL L=50e-9 W='1*90e-9'
mn298 col<106> sel<1> 0 0 NMOS_VTL L=50e-9 W='1*90e-9'
mn299 col<107> sel<1> 0 0 NMOS_VTL L=50e-9 W='1*90e-9'
mn301 col<109> sel<1> 0 0 NMOS_VTL L=50e-9 W='1*90e-9'
mn309 col<117> sel<1> 0 0 NMOS_VTL L=50e-9 W='1*90e-9'
mn310 col<118> sel<1> 0 0 NMOS_VTL L=50e-9 W='1*90e-9'
mn311 col<119> sel<1> 0 0 NMOS_VTL L=50e-9 W='1*90e-9'
mn316 col<124> sel<1> 0 0 NMOS_VTL L=50e-9 W='1*90e-9'
mn317 col<125> sel<1> 0 0 NMOS_VTL L=50e-9 W='1*90e-9'
mn319 col<127> sel<1> 0 0 NMOS_VTL L=50e-9 W='1*90e-9'
mn320 col<128> sel<1> 0 0 NMOS_VTL L=50e-9 W='1*90e-9'
mn324 col<132> sel<1> 0 0 NMOS_VTL L=50e-9 W='1*90e-9'
mn327 col<135> sel<1> 0 0 NMOS_VTL L=50e-9 W='1*90e-9'
mn328 col<136> sel<1> 0 0 NMOS_VTL L=50e-9 W='1*90e-9'
mn329 col<137> sel<1> 0 0 NMOS_VTL L=50e-9 W='1*90e-9'
mn331 col<139> sel<1> 0 0 NMOS_VTL L=50e-9 W='1*90e-9'
mn332 col<140> sel<1> 0 0 NMOS_VTL L=50e-9 W='1*90e-9'
mn333 col<141> sel<1> 0 0 NMOS_VTL L=50e-9 W='1*90e-9'
mn334 col<142> sel<1> 0 0 NMOS_VTL L=50e-9 W='1*90e-9'
mn335 col<143> sel<1> 0 0 NMOS_VTL L=50e-9 W='1*90e-9'
mn340 col<148> sel<1> 0 0 NMOS_VTL L=50e-9 W='1*90e-9'
mn341 col<149> sel<1> 0 0 NMOS_VTL L=50e-9 W='1*90e-9'
mn342 col<150> sel<1> 0 0 NMOS_VTL L=50e-9 W='1*90e-9'
mn344 col<152> sel<1> 0 0 NMOS_VTL L=50e-9 W='1*90e-9'
mn345 col<153> sel<1> 0 0 NMOS_VTL L=50e-9 W='1*90e-9'
mn346 col<154> sel<1> 0 0 NMOS_VTL L=50e-9 W='1*90e-9'
mn347 col<155> sel<1> 0 0 NMOS_VTL L=50e-9 W='1*90e-9'
mn348 col<156> sel<1> 0 0 NMOS_VTL L=50e-9 W='1*90e-9'
mn349 col<157> sel<1> 0 0 NMOS_VTL L=50e-9 W='1*90e-9'
mn350 col<158> sel<1> 0 0 NMOS_VTL L=50e-9 W='1*90e-9'
mn351 col<159> sel<1> 0 0 NMOS_VTL L=50e-9 W='1*90e-9'
mn352 col<160> sel<1> 0 0 NMOS_VTL L=50e-9 W='1*90e-9'
mn353 col<161> sel<1> 0 0 NMOS_VTL L=50e-9 W='1*90e-9'
mn355 col<163> sel<1> 0 0 NMOS_VTL L=50e-9 W='1*90e-9'
mn356 col<164> sel<1> 0 0 NMOS_VTL L=50e-9 W='1*90e-9'
mn360 col<168> sel<1> 0 0 NMOS_VTL L=50e-9 W='1*90e-9'
mn361 col<169> sel<1> 0 0 NMOS_VTL L=50e-9 W='1*90e-9'
mn362 col<170> sel<1> 0 0 NMOS_VTL L=50e-9 W='1*90e-9'
mn363 col<171> sel<1> 0 0 NMOS_VTL L=50e-9 W='1*90e-9'
mn364 col<172> sel<1> 0 0 NMOS_VTL L=50e-9 W='1*90e-9'
mn365 col<173> sel<1> 0 0 NMOS_VTL L=50e-9 W='1*90e-9'
mn369 col<177> sel<1> 0 0 NMOS_VTL L=50e-9 W='1*90e-9'
mn375 col<183> sel<1> 0 0 NMOS_VTL L=50e-9 W='1*90e-9'
mn378 col<186> sel<1> 0 0 NMOS_VTL L=50e-9 W='1*90e-9'
mn379 col<187> sel<1> 0 0 NMOS_VTL L=50e-9 W='1*90e-9'
mn380 col<188> sel<1> 0 0 NMOS_VTL L=50e-9 W='1*90e-9'
mn381 col<189> sel<1> 0 0 NMOS_VTL L=50e-9 W='1*90e-9'
mn382 col<190> sel<1> 0 0 NMOS_VTL L=50e-9 W='1*90e-9'
mn383 col<191> sel<1> 0 0 NMOS_VTL L=50e-9 W='1*90e-9'
mn384 col<0> sel<2> 0 0 NMOS_VTL L=50e-9 W='1*90e-9'
mn385 col<1> sel<2> 0 0 NMOS_VTL L=50e-9 W='1*90e-9'
mn386 col<2> sel<2> 0 0 NMOS_VTL L=50e-9 W='1*90e-9'
mn387 col<3> sel<2> 0 0 NMOS_VTL L=50e-9 W='1*90e-9'
mn388 col<4> sel<2> 0 0 NMOS_VTL L=50e-9 W='1*90e-9'
mn389 col<5> sel<2> 0 0 NMOS_VTL L=50e-9 W='1*90e-9'
mn390 col<6> sel<2> 0 0 NMOS_VTL L=50e-9 W='1*90e-9'
mn391 col<7> sel<2> 0 0 NMOS_VTL L=50e-9 W='1*90e-9'
mn392 col<8> sel<2> 0 0 NMOS_VTL L=50e-9 W='1*90e-9'
mn393 col<9> sel<2> 0 0 NMOS_VTL L=50e-9 W='1*90e-9'
mn394 col<10> sel<2> 0 0 NMOS_VTL L=50e-9 W='1*90e-9'
mn395 col<11> sel<2> 0 0 NMOS_VTL L=50e-9 W='1*90e-9'
mn408 col<24> sel<2> 0 0 NMOS_VTL L=50e-9 W='1*90e-9'
mn409 col<25> sel<2> 0 0 NMOS_VTL L=50e-9 W='1*90e-9'
mn410 col<26> sel<2> 0 0 NMOS_VTL L=50e-9 W='1*90e-9'
mn417 col<33> sel<2> 0 0 NMOS_VTL L=50e-9 W='1*90e-9'
mn418 col<34> sel<2> 0 0 NMOS_VTL L=50e-9 W='1*90e-9'
mn419 col<35> sel<2> 0 0 NMOS_VTL L=50e-9 W='1*90e-9'
mn420 col<36> sel<2> 0 0 NMOS_VTL L=50e-9 W='1*90e-9'
mn421 col<37> sel<2> 0 0 NMOS_VTL L=50e-9 W='1*90e-9'
mn422 col<38> sel<2> 0 0 NMOS_VTL L=50e-9 W='1*90e-9'
mn423 col<39> sel<2> 0 0 NMOS_VTL L=50e-9 W='1*90e-9'
mn424 col<40> sel<2> 0 0 NMOS_VTL L=50e-9 W='1*90e-9'
mn425 col<41> sel<2> 0 0 NMOS_VTL L=50e-9 W='1*90e-9'
mn433 col<49> sel<2> 0 0 NMOS_VTL L=50e-9 W='1*90e-9'
mn434 col<50> sel<2> 0 0 NMOS_VTL L=50e-9 W='1*90e-9'
mn435 col<51> sel<2> 0 0 NMOS_VTL L=50e-9 W='1*90e-9'
mn436 col<52> sel<2> 0 0 NMOS_VTL L=50e-9 W='1*90e-9'
mn437 col<53> sel<2> 0 0 NMOS_VTL L=50e-9 W='1*90e-9'
mn441 col<57> sel<2> 0 0 NMOS_VTL L=50e-9 W='1*90e-9'
mn442 col<58> sel<2> 0 0 NMOS_VTL L=50e-9 W='1*90e-9'
mn443 col<59> sel<2> 0 0 NMOS_VTL L=50e-9 W='1*90e-9'
mn444 col<60> sel<2> 0 0 NMOS_VTL L=50e-9 W='1*90e-9'
mn445 col<61> sel<2> 0 0 NMOS_VTL L=50e-9 W='1*90e-9'
mn446 col<62> sel<2> 0 0 NMOS_VTL L=50e-9 W='1*90e-9'
mn447 col<63> sel<2> 0 0 NMOS_VTL L=50e-9 W='1*90e-9'
mn448 col<64> sel<2> 0 0 NMOS_VTL L=50e-9 W='1*90e-9'
mn449 col<65> sel<2> 0 0 NMOS_VTL L=50e-9 W='1*90e-9'
mn457 col<73> sel<2> 0 0 NMOS_VTL L=50e-9 W='1*90e-9'
mn458 col<74> sel<2> 0 0 NMOS_VTL L=50e-9 W='1*90e-9'
mn465 col<81> sel<2> 0 0 NMOS_VTL L=50e-9 W='1*90e-9'
mn468 col<84> sel<2> 0 0 NMOS_VTL L=50e-9 W='1*90e-9'
mn471 col<87> sel<2> 0 0 NMOS_VTL L=50e-9 W='1*90e-9'
mn472 col<88> sel<2> 0 0 NMOS_VTL L=50e-9 W='1*90e-9'
mn473 col<89> sel<2> 0 0 NMOS_VTL L=50e-9 W='1*90e-9'
mn475 col<91> sel<2> 0 0 NMOS_VTL L=50e-9 W='1*90e-9'
mn476 col<92> sel<2> 0 0 NMOS_VTL L=50e-9 W='1*90e-9'
mn481 col<97> sel<2> 0 0 NMOS_VTL L=50e-9 W='1*90e-9'
mn482 col<98> sel<2> 0 0 NMOS_VTL L=50e-9 W='1*90e-9'
mn489 col<105> sel<2> 0 0 NMOS_VTL L=50e-9 W='1*90e-9'
mn490 col<106> sel<2> 0 0 NMOS_VTL L=50e-9 W='1*90e-9'
mn491 col<107> sel<2> 0 0 NMOS_VTL L=50e-9 W='1*90e-9'
mn496 col<112> sel<2> 0 0 NMOS_VTL L=50e-9 W='1*90e-9'
mn498 col<114> sel<2> 0 0 NMOS_VTL L=50e-9 W='1*90e-9'
mn499 col<115> sel<2> 0 0 NMOS_VTL L=50e-9 W='1*90e-9'
mn500 col<116> sel<2> 0 0 NMOS_VTL L=50e-9 W='1*90e-9'
mn501 col<117> sel<2> 0 0 NMOS_VTL L=50e-9 W='1*90e-9'
mn502 col<118> sel<2> 0 0 NMOS_VTL L=50e-9 W='1*90e-9'
mn503 col<119> sel<2> 0 0 NMOS_VTL L=50e-9 W='1*90e-9'
mn508 col<124> sel<2> 0 0 NMOS_VTL L=50e-9 W='1*90e-9'
mn509 col<125> sel<2> 0 0 NMOS_VTL L=50e-9 W='1*90e-9'
mn510 col<126> sel<2> 0 0 NMOS_VTL L=50e-9 W='1*90e-9'
mn511 col<127> sel<2> 0 0 NMOS_VTL L=50e-9 W='1*90e-9'
mn512 col<128> sel<2> 0 0 NMOS_VTL L=50e-9 W='1*90e-9'
mn514 col<130> sel<2> 0 0 NMOS_VTL L=50e-9 W='1*90e-9'
mn515 col<131> sel<2> 0 0 NMOS_VTL L=50e-9 W='1*90e-9'
mn516 col<132> sel<2> 0 0 NMOS_VTL L=50e-9 W='1*90e-9'
mn519 col<135> sel<2> 0 0 NMOS_VTL L=50e-9 W='1*90e-9'
mn525 col<141> sel<2> 0 0 NMOS_VTL L=50e-9 W='1*90e-9'
mn526 col<142> sel<2> 0 0 NMOS_VTL L=50e-9 W='1*90e-9'
mn527 col<143> sel<2> 0 0 NMOS_VTL L=50e-9 W='1*90e-9'
mn537 col<153> sel<2> 0 0 NMOS_VTL L=50e-9 W='1*90e-9'
mn538 col<154> sel<2> 0 0 NMOS_VTL L=50e-9 W='1*90e-9'
mn539 col<155> sel<2> 0 0 NMOS_VTL L=50e-9 W='1*90e-9'
mn547 col<163> sel<2> 0 0 NMOS_VTL L=50e-9 W='1*90e-9'
mn548 col<164> sel<2> 0 0 NMOS_VTL L=50e-9 W='1*90e-9'
mn549 col<165> sel<2> 0 0 NMOS_VTL L=50e-9 W='1*90e-9'
mn550 col<166> sel<2> 0 0 NMOS_VTL L=50e-9 W='1*90e-9'
mn551 col<167> sel<2> 0 0 NMOS_VTL L=50e-9 W='1*90e-9'
mn552 col<168> sel<2> 0 0 NMOS_VTL L=50e-9 W='1*90e-9'
mn553 col<169> sel<2> 0 0 NMOS_VTL L=50e-9 W='1*90e-9'
mn554 col<170> sel<2> 0 0 NMOS_VTL L=50e-9 W='1*90e-9'
mn555 col<171> sel<2> 0 0 NMOS_VTL L=50e-9 W='1*90e-9'
mn556 col<172> sel<2> 0 0 NMOS_VTL L=50e-9 W='1*90e-9'
mn557 col<173> sel<2> 0 0 NMOS_VTL L=50e-9 W='1*90e-9'
mn561 col<177> sel<2> 0 0 NMOS_VTL L=50e-9 W='1*90e-9'
mn562 col<178> sel<2> 0 0 NMOS_VTL L=50e-9 W='1*90e-9'
mn563 col<179> sel<2> 0 0 NMOS_VTL L=50e-9 W='1*90e-9'
mn564 col<180> sel<2> 0 0 NMOS_VTL L=50e-9 W='1*90e-9'
mn565 col<181> sel<2> 0 0 NMOS_VTL L=50e-9 W='1*90e-9'
mn566 col<182> sel<2> 0 0 NMOS_VTL L=50e-9 W='1*90e-9'
mn567 col<183> sel<2> 0 0 NMOS_VTL L=50e-9 W='1*90e-9'
mn568 col<184> sel<2> 0 0 NMOS_VTL L=50e-9 W='1*90e-9'
mn569 col<185> sel<2> 0 0 NMOS_VTL L=50e-9 W='1*90e-9'
mn570 col<186> sel<2> 0 0 NMOS_VTL L=50e-9 W='1*90e-9'
mn571 col<187> sel<2> 0 0 NMOS_VTL L=50e-9 W='1*90e-9'
mn572 col<188> sel<2> 0 0 NMOS_VTL L=50e-9 W='1*90e-9'
mn573 col<189> sel<2> 0 0 NMOS_VTL L=50e-9 W='1*90e-9'
mn574 col<190> sel<2> 0 0 NMOS_VTL L=50e-9 W='1*90e-9'
mn575 col<191> sel<2> 0 0 NMOS_VTL L=50e-9 W='1*90e-9'
mn576 col<0> sel<3> 0 0 NMOS_VTL L=50e-9 W='1*90e-9'
mn577 col<1> sel<3> 0 0 NMOS_VTL L=50e-9 W='1*90e-9'
mn578 col<2> sel<3> 0 0 NMOS_VTL L=50e-9 W='1*90e-9'
mn585 col<9> sel<3> 0 0 NMOS_VTL L=50e-9 W='1*90e-9'
mn586 col<10> sel<3> 0 0 NMOS_VTL L=50e-9 W='1*90e-9'
mn587 col<11> sel<3> 0 0 NMOS_VTL L=50e-9 W='1*90e-9'
mn588 col<12> sel<3> 0 0 NMOS_VTL L=50e-9 W='1*90e-9'
mn589 col<13> sel<3> 0 0 NMOS_VTL L=50e-9 W='1*90e-9'
mn590 col<14> sel<3> 0 0 NMOS_VTL L=50e-9 W='1*90e-9'
mn591 col<15> sel<3> 0 0 NMOS_VTL L=50e-9 W='1*90e-9'
mn592 col<16> sel<3> 0 0 NMOS_VTL L=50e-9 W='1*90e-9'
mn593 col<17> sel<3> 0 0 NMOS_VTL L=50e-9 W='1*90e-9'
mn597 col<21> sel<3> 0 0 NMOS_VTL L=50e-9 W='1*90e-9'
mn598 col<22> sel<3> 0 0 NMOS_VTL L=50e-9 W='1*90e-9'
mn599 col<23> sel<3> 0 0 NMOS_VTL L=50e-9 W='1*90e-9'
mn600 col<24> sel<3> 0 0 NMOS_VTL L=50e-9 W='1*90e-9'
mn601 col<25> sel<3> 0 0 NMOS_VTL L=50e-9 W='1*90e-9'
mn602 col<26> sel<3> 0 0 NMOS_VTL L=50e-9 W='1*90e-9'
mn609 col<33> sel<3> 0 0 NMOS_VTL L=50e-9 W='1*90e-9'
mn610 col<34> sel<3> 0 0 NMOS_VTL L=50e-9 W='1*90e-9'
mn611 col<35> sel<3> 0 0 NMOS_VTL L=50e-9 W='1*90e-9'
mn618 col<42> sel<3> 0 0 NMOS_VTL L=50e-9 W='1*90e-9'
mn619 col<43> sel<3> 0 0 NMOS_VTL L=50e-9 W='1*90e-9'
mn620 col<44> sel<3> 0 0 NMOS_VTL L=50e-9 W='1*90e-9'
mn621 col<45> sel<3> 0 0 NMOS_VTL L=50e-9 W='1*90e-9'
mn622 col<46> sel<3> 0 0 NMOS_VTL L=50e-9 W='1*90e-9'
mn623 col<47> sel<3> 0 0 NMOS_VTL L=50e-9 W='1*90e-9'
mn624 col<48> sel<3> 0 0 NMOS_VTL L=50e-9 W='1*90e-9'
mn625 col<49> sel<3> 0 0 NMOS_VTL L=50e-9 W='1*90e-9'
mn626 col<50> sel<3> 0 0 NMOS_VTL L=50e-9 W='1*90e-9'
mn631 col<55> sel<3> 0 0 NMOS_VTL L=50e-9 W='1*90e-9'
mn632 col<56> sel<3> 0 0 NMOS_VTL L=50e-9 W='1*90e-9'
mn634 col<58> sel<3> 0 0 NMOS_VTL L=50e-9 W='1*90e-9'
mn635 col<59> sel<3> 0 0 NMOS_VTL L=50e-9 W='1*90e-9'
mn639 col<63> sel<3> 0 0 NMOS_VTL L=50e-9 W='1*90e-9'
mn640 col<64> sel<3> 0 0 NMOS_VTL L=50e-9 W='1*90e-9'
mn641 col<65> sel<3> 0 0 NMOS_VTL L=50e-9 W='1*90e-9'
mn643 col<67> sel<3> 0 0 NMOS_VTL L=50e-9 W='1*90e-9'
mn644 col<68> sel<3> 0 0 NMOS_VTL L=50e-9 W='1*90e-9'
mn645 col<69> sel<3> 0 0 NMOS_VTL L=50e-9 W='1*90e-9'
mn646 col<70> sel<3> 0 0 NMOS_VTL L=50e-9 W='1*90e-9'
mn647 col<71> sel<3> 0 0 NMOS_VTL L=50e-9 W='1*90e-9'
mn648 col<72> sel<3> 0 0 NMOS_VTL L=50e-9 W='1*90e-9'
mn649 col<73> sel<3> 0 0 NMOS_VTL L=50e-9 W='1*90e-9'
mn650 col<74> sel<3> 0 0 NMOS_VTL L=50e-9 W='1*90e-9'
mn651 col<75> sel<3> 0 0 NMOS_VTL L=50e-9 W='1*90e-9'
mn652 col<76> sel<3> 0 0 NMOS_VTL L=50e-9 W='1*90e-9'
mn653 col<77> sel<3> 0 0 NMOS_VTL L=50e-9 W='1*90e-9'
mn654 col<78> sel<3> 0 0 NMOS_VTL L=50e-9 W='1*90e-9'
mn655 col<79> sel<3> 0 0 NMOS_VTL L=50e-9 W='1*90e-9'
mn656 col<80> sel<3> 0 0 NMOS_VTL L=50e-9 W='1*90e-9'
mn663 col<87> sel<3> 0 0 NMOS_VTL L=50e-9 W='1*90e-9'
mn664 col<88> sel<3> 0 0 NMOS_VTL L=50e-9 W='1*90e-9'
mn665 col<89> sel<3> 0 0 NMOS_VTL L=50e-9 W='1*90e-9'
mn669 col<93> sel<3> 0 0 NMOS_VTL L=50e-9 W='1*90e-9'
mn670 col<94> sel<3> 0 0 NMOS_VTL L=50e-9 W='1*90e-9'
mn671 col<95> sel<3> 0 0 NMOS_VTL L=50e-9 W='1*90e-9'
mn672 col<96> sel<3> 0 0 NMOS_VTL L=50e-9 W='1*90e-9'
mn673 col<97> sel<3> 0 0 NMOS_VTL L=50e-9 W='1*90e-9'
mn674 col<98> sel<3> 0 0 NMOS_VTL L=50e-9 W='1*90e-9'
mn679 col<103> sel<3> 0 0 NMOS_VTL L=50e-9 W='1*90e-9'
mn680 col<104> sel<3> 0 0 NMOS_VTL L=50e-9 W='1*90e-9'
mn684 col<108> sel<3> 0 0 NMOS_VTL L=50e-9 W='1*90e-9'
mn685 col<109> sel<3> 0 0 NMOS_VTL L=50e-9 W='1*90e-9'
mn686 col<110> sel<3> 0 0 NMOS_VTL L=50e-9 W='1*90e-9'
mn688 col<112> sel<3> 0 0 NMOS_VTL L=50e-9 W='1*90e-9'
mn689 col<113> sel<3> 0 0 NMOS_VTL L=50e-9 W='1*90e-9'
mn691 col<115> sel<3> 0 0 NMOS_VTL L=50e-9 W='1*90e-9'
mn692 col<116> sel<3> 0 0 NMOS_VTL L=50e-9 W='1*90e-9'
mn693 col<117> sel<3> 0 0 NMOS_VTL L=50e-9 W='1*90e-9'
mn694 col<118> sel<3> 0 0 NMOS_VTL L=50e-9 W='1*90e-9'
mn695 col<119> sel<3> 0 0 NMOS_VTL L=50e-9 W='1*90e-9'
mn702 col<126> sel<3> 0 0 NMOS_VTL L=50e-9 W='1*90e-9'
mn703 col<127> sel<3> 0 0 NMOS_VTL L=50e-9 W='1*90e-9'
mn704 col<128> sel<3> 0 0 NMOS_VTL L=50e-9 W='1*90e-9'
mn705 col<129> sel<3> 0 0 NMOS_VTL L=50e-9 W='1*90e-9'
mn706 col<130> sel<3> 0 0 NMOS_VTL L=50e-9 W='1*90e-9'
mn707 col<131> sel<3> 0 0 NMOS_VTL L=50e-9 W='1*90e-9'
mn708 col<132> sel<3> 0 0 NMOS_VTL L=50e-9 W='1*90e-9'
mn709 col<133> sel<3> 0 0 NMOS_VTL L=50e-9 W='1*90e-9'
mn710 col<134> sel<3> 0 0 NMOS_VTL L=50e-9 W='1*90e-9'
mn711 col<135> sel<3> 0 0 NMOS_VTL L=50e-9 W='1*90e-9'
mn712 col<136> sel<3> 0 0 NMOS_VTL L=50e-9 W='1*90e-9'
mn713 col<137> sel<3> 0 0 NMOS_VTL L=50e-9 W='1*90e-9'
mn714 col<138> sel<3> 0 0 NMOS_VTL L=50e-9 W='1*90e-9'
mn715 col<139> sel<3> 0 0 NMOS_VTL L=50e-9 W='1*90e-9'
mn716 col<140> sel<3> 0 0 NMOS_VTL L=50e-9 W='1*90e-9'
mn723 col<147> sel<3> 0 0 NMOS_VTL L=50e-9 W='1*90e-9'
mn724 col<148> sel<3> 0 0 NMOS_VTL L=50e-9 W='1*90e-9'
mn725 col<149> sel<3> 0 0 NMOS_VTL L=50e-9 W='1*90e-9'
mn726 col<150> sel<3> 0 0 NMOS_VTL L=50e-9 W='1*90e-9'
mn727 col<151> sel<3> 0 0 NMOS_VTL L=50e-9 W='1*90e-9'
mn728 col<152> sel<3> 0 0 NMOS_VTL L=50e-9 W='1*90e-9'
mn729 col<153> sel<3> 0 0 NMOS_VTL L=50e-9 W='1*90e-9'
mn730 col<154> sel<3> 0 0 NMOS_VTL L=50e-9 W='1*90e-9'
mn731 col<155> sel<3> 0 0 NMOS_VTL L=50e-9 W='1*90e-9'
mn732 col<156> sel<3> 0 0 NMOS_VTL L=50e-9 W='1*90e-9'
mn733 col<157> sel<3> 0 0 NMOS_VTL L=50e-9 W='1*90e-9'
mn734 col<158> sel<3> 0 0 NMOS_VTL L=50e-9 W='1*90e-9'
mn735 col<159> sel<3> 0 0 NMOS_VTL L=50e-9 W='1*90e-9'
mn736 col<160> sel<3> 0 0 NMOS_VTL L=50e-9 W='1*90e-9'
mn737 col<161> sel<3> 0 0 NMOS_VTL L=50e-9 W='1*90e-9'
mn741 col<165> sel<3> 0 0 NMOS_VTL L=50e-9 W='1*90e-9'
mn742 col<166> sel<3> 0 0 NMOS_VTL L=50e-9 W='1*90e-9'
mn743 col<167> sel<3> 0 0 NMOS_VTL L=50e-9 W='1*90e-9'
mn744 col<168> sel<3> 0 0 NMOS_VTL L=50e-9 W='1*90e-9'
mn745 col<169> sel<3> 0 0 NMOS_VTL L=50e-9 W='1*90e-9'
mn746 col<170> sel<3> 0 0 NMOS_VTL L=50e-9 W='1*90e-9'
mn747 col<171> sel<3> 0 0 NMOS_VTL L=50e-9 W='1*90e-9'
mn748 col<172> sel<3> 0 0 NMOS_VTL L=50e-9 W='1*90e-9'
mn749 col<173> sel<3> 0 0 NMOS_VTL L=50e-9 W='1*90e-9'
mn750 col<174> sel<3> 0 0 NMOS_VTL L=50e-9 W='1*90e-9'
mn751 col<175> sel<3> 0 0 NMOS_VTL L=50e-9 W='1*90e-9'
mn752 col<176> sel<3> 0 0 NMOS_VTL L=50e-9 W='1*90e-9'
mn753 col<177> sel<3> 0 0 NMOS_VTL L=50e-9 W='1*90e-9'
mn754 col<178> sel<3> 0 0 NMOS_VTL L=50e-9 W='1*90e-9'
mn755 col<179> sel<3> 0 0 NMOS_VTL L=50e-9 W='1*90e-9'
mn756 col<180> sel<3> 0 0 NMOS_VTL L=50e-9 W='1*90e-9'
mn757 col<181> sel<3> 0 0 NMOS_VTL L=50e-9 W='1*90e-9'
mn758 col<182> sel<3> 0 0 NMOS_VTL L=50e-9 W='1*90e-9'
mn762 col<186> sel<3> 0 0 NMOS_VTL L=50e-9 W='1*90e-9'
mn763 col<187> sel<3> 0 0 NMOS_VTL L=50e-9 W='1*90e-9'
mn764 col<188> sel<3> 0 0 NMOS_VTL L=50e-9 W='1*90e-9'
mn771 col<3> sel<4> 0 0 NMOS_VTL L=50e-9 W='1*90e-9'
mn772 col<4> sel<4> 0 0 NMOS_VTL L=50e-9 W='1*90e-9'
mn773 col<5> sel<4> 0 0 NMOS_VTL L=50e-9 W='1*90e-9'
mn780 col<12> sel<4> 0 0 NMOS_VTL L=50e-9 W='1*90e-9'
mn781 col<13> sel<4> 0 0 NMOS_VTL L=50e-9 W='1*90e-9'
mn782 col<14> sel<4> 0 0 NMOS_VTL L=50e-9 W='1*90e-9'
mn783 col<15> sel<4> 0 0 NMOS_VTL L=50e-9 W='1*90e-9'
mn784 col<16> sel<4> 0 0 NMOS_VTL L=50e-9 W='1*90e-9'
mn785 col<17> sel<4> 0 0 NMOS_VTL L=50e-9 W='1*90e-9'
mn786 col<18> sel<4> 0 0 NMOS_VTL L=50e-9 W='1*90e-9'
mn787 col<19> sel<4> 0 0 NMOS_VTL L=50e-9 W='1*90e-9'
mn788 col<20> sel<4> 0 0 NMOS_VTL L=50e-9 W='1*90e-9'
mn789 col<21> sel<4> 0 0 NMOS_VTL L=50e-9 W='1*90e-9'
mn790 col<22> sel<4> 0 0 NMOS_VTL L=50e-9 W='1*90e-9'
mn791 col<23> sel<4> 0 0 NMOS_VTL L=50e-9 W='1*90e-9'
mn798 col<30> sel<4> 0 0 NMOS_VTL L=50e-9 W='1*90e-9'
mn799 col<31> sel<4> 0 0 NMOS_VTL L=50e-9 W='1*90e-9'
mn800 col<32> sel<4> 0 0 NMOS_VTL L=50e-9 W='1*90e-9'
mn801 col<33> sel<4> 0 0 NMOS_VTL L=50e-9 W='1*90e-9'
mn802 col<34> sel<4> 0 0 NMOS_VTL L=50e-9 W='1*90e-9'
mn803 col<35> sel<4> 0 0 NMOS_VTL L=50e-9 W='1*90e-9'
mn807 col<39> sel<4> 0 0 NMOS_VTL L=50e-9 W='1*90e-9'
mn808 col<40> sel<4> 0 0 NMOS_VTL L=50e-9 W='1*90e-9'
mn809 col<41> sel<4> 0 0 NMOS_VTL L=50e-9 W='1*90e-9'
mn819 col<51> sel<4> 0 0 NMOS_VTL L=50e-9 W='1*90e-9'
mn820 col<52> sel<4> 0 0 NMOS_VTL L=50e-9 W='1*90e-9'
mn821 col<53> sel<4> 0 0 NMOS_VTL L=50e-9 W='1*90e-9'
mn822 col<54> sel<4> 0 0 NMOS_VTL L=50e-9 W='1*90e-9'
mn823 col<55> sel<4> 0 0 NMOS_VTL L=50e-9 W='1*90e-9'
mn824 col<56> sel<4> 0 0 NMOS_VTL L=50e-9 W='1*90e-9'
mn825 col<57> sel<4> 0 0 NMOS_VTL L=50e-9 W='1*90e-9'
mn826 col<58> sel<4> 0 0 NMOS_VTL L=50e-9 W='1*90e-9'
mn827 col<59> sel<4> 0 0 NMOS_VTL L=50e-9 W='1*90e-9'
mn828 col<60> sel<4> 0 0 NMOS_VTL L=50e-9 W='1*90e-9'
mn829 col<61> sel<4> 0 0 NMOS_VTL L=50e-9 W='1*90e-9'
mn830 col<62> sel<4> 0 0 NMOS_VTL L=50e-9 W='1*90e-9'
mn831 col<63> sel<4> 0 0 NMOS_VTL L=50e-9 W='1*90e-9'
mn832 col<64> sel<4> 0 0 NMOS_VTL L=50e-9 W='1*90e-9'
mn833 col<65> sel<4> 0 0 NMOS_VTL L=50e-9 W='1*90e-9'
mn834 col<66> sel<4> 0 0 NMOS_VTL L=50e-9 W='1*90e-9'
mn835 col<67> sel<4> 0 0 NMOS_VTL L=50e-9 W='1*90e-9'
mn836 col<68> sel<4> 0 0 NMOS_VTL L=50e-9 W='1*90e-9'
mn849 col<81> sel<4> 0 0 NMOS_VTL L=50e-9 W='1*90e-9'
mn850 col<82> sel<4> 0 0 NMOS_VTL L=50e-9 W='1*90e-9'
mn851 col<83> sel<4> 0 0 NMOS_VTL L=50e-9 W='1*90e-9'
mn852 col<84> sel<4> 0 0 NMOS_VTL L=50e-9 W='1*90e-9'
mn853 col<85> sel<4> 0 0 NMOS_VTL L=50e-9 W='1*90e-9'
mn854 col<86> sel<4> 0 0 NMOS_VTL L=50e-9 W='1*90e-9'
mn864 col<96> sel<4> 0 0 NMOS_VTL L=50e-9 W='1*90e-9'
mn865 col<97> sel<4> 0 0 NMOS_VTL L=50e-9 W='1*90e-9'
mn866 col<98> sel<4> 0 0 NMOS_VTL L=50e-9 W='1*90e-9'
mn867 col<99> sel<4> 0 0 NMOS_VTL L=50e-9 W='1*90e-9'
mn868 col<100> sel<4> 0 0 NMOS_VTL L=50e-9 W='1*90e-9'
mn869 col<101> sel<4> 0 0 NMOS_VTL L=50e-9 W='1*90e-9'
mn870 col<102> sel<4> 0 0 NMOS_VTL L=50e-9 W='1*90e-9'
mn871 col<103> sel<4> 0 0 NMOS_VTL L=50e-9 W='1*90e-9'
mn872 col<104> sel<4> 0 0 NMOS_VTL L=50e-9 W='1*90e-9'
mn873 col<105> sel<4> 0 0 NMOS_VTL L=50e-9 W='1*90e-9'
mn874 col<106> sel<4> 0 0 NMOS_VTL L=50e-9 W='1*90e-9'
mn875 col<107> sel<4> 0 0 NMOS_VTL L=50e-9 W='1*90e-9'
mn876 col<108> sel<4> 0 0 NMOS_VTL L=50e-9 W='1*90e-9'
mn877 col<109> sel<4> 0 0 NMOS_VTL L=50e-9 W='1*90e-9'
mn878 col<110> sel<4> 0 0 NMOS_VTL L=50e-9 W='1*90e-9'
mn882 col<114> sel<4> 0 0 NMOS_VTL L=50e-9 W='1*90e-9'
mn883 col<115> sel<4> 0 0 NMOS_VTL L=50e-9 W='1*90e-9'
mn884 col<116> sel<4> 0 0 NMOS_VTL L=50e-9 W='1*90e-9'
mn897 col<129> sel<4> 0 0 NMOS_VTL L=50e-9 W='1*90e-9'
mn898 col<130> sel<4> 0 0 NMOS_VTL L=50e-9 W='1*90e-9'
mn899 col<131> sel<4> 0 0 NMOS_VTL L=50e-9 W='1*90e-9'
mn909 col<141> sel<4> 0 0 NMOS_VTL L=50e-9 W='1*90e-9'
mn910 col<142> sel<4> 0 0 NMOS_VTL L=50e-9 W='1*90e-9'
mn911 col<143> sel<4> 0 0 NMOS_VTL L=50e-9 W='1*90e-9'
mn915 col<147> sel<4> 0 0 NMOS_VTL L=50e-9 W='1*90e-9'
mn916 col<148> sel<4> 0 0 NMOS_VTL L=50e-9 W='1*90e-9'
mn917 col<149> sel<4> 0 0 NMOS_VTL L=50e-9 W='1*90e-9'
mn924 col<156> sel<4> 0 0 NMOS_VTL L=50e-9 W='1*90e-9'
mn925 col<157> sel<4> 0 0 NMOS_VTL L=50e-9 W='1*90e-9'
mn926 col<158> sel<4> 0 0 NMOS_VTL L=50e-9 W='1*90e-9'
mn927 col<159> sel<4> 0 0 NMOS_VTL L=50e-9 W='1*90e-9'
mn928 col<160> sel<4> 0 0 NMOS_VTL L=50e-9 W='1*90e-9'
mn929 col<161> sel<4> 0 0 NMOS_VTL L=50e-9 W='1*90e-9'
mn933 col<165> sel<4> 0 0 NMOS_VTL L=50e-9 W='1*90e-9'
mn934 col<166> sel<4> 0 0 NMOS_VTL L=50e-9 W='1*90e-9'
mn935 col<167> sel<4> 0 0 NMOS_VTL L=50e-9 W='1*90e-9'
mn936 col<168> sel<4> 0 0 NMOS_VTL L=50e-9 W='1*90e-9'
mn937 col<169> sel<4> 0 0 NMOS_VTL L=50e-9 W='1*90e-9'
mn938 col<170> sel<4> 0 0 NMOS_VTL L=50e-9 W='1*90e-9'
mn939 col<171> sel<4> 0 0 NMOS_VTL L=50e-9 W='1*90e-9'
mn940 col<172> sel<4> 0 0 NMOS_VTL L=50e-9 W='1*90e-9'
mn941 col<173> sel<4> 0 0 NMOS_VTL L=50e-9 W='1*90e-9'
mn951 col<183> sel<4> 0 0 NMOS_VTL L=50e-9 W='1*90e-9'
mn952 col<184> sel<4> 0 0 NMOS_VTL L=50e-9 W='1*90e-9'
mn953 col<185> sel<4> 0 0 NMOS_VTL L=50e-9 W='1*90e-9'
mn954 col<186> sel<4> 0 0 NMOS_VTL L=50e-9 W='1*90e-9'
mn955 col<187> sel<4> 0 0 NMOS_VTL L=50e-9 W='1*90e-9'
mn956 col<188> sel<4> 0 0 NMOS_VTL L=50e-9 W='1*90e-9'
mn963 col<3> sel<5> 0 0 NMOS_VTL L=50e-9 W='1*90e-9'
mn964 col<4> sel<5> 0 0 NMOS_VTL L=50e-9 W='1*90e-9'
mn965 col<5> sel<5> 0 0 NMOS_VTL L=50e-9 W='1*90e-9'
mn966 col<6> sel<5> 0 0 NMOS_VTL L=50e-9 W='1*90e-9'
mn967 col<7> sel<5> 0 0 NMOS_VTL L=50e-9 W='1*90e-9'
mn968 col<8> sel<5> 0 0 NMOS_VTL L=50e-9 W='1*90e-9'
mn969 col<9> sel<5> 0 0 NMOS_VTL L=50e-9 W='1*90e-9'
mn970 col<10> sel<5> 0 0 NMOS_VTL L=50e-9 W='1*90e-9'
mn971 col<11> sel<5> 0 0 NMOS_VTL L=50e-9 W='1*90e-9'
mn978 col<18> sel<5> 0 0 NMOS_VTL L=50e-9 W='1*90e-9'
mn979 col<19> sel<5> 0 0 NMOS_VTL L=50e-9 W='1*90e-9'
mn980 col<20> sel<5> 0 0 NMOS_VTL L=50e-9 W='1*90e-9'
mn981 col<21> sel<5> 0 0 NMOS_VTL L=50e-9 W='1*90e-9'
mn982 col<22> sel<5> 0 0 NMOS_VTL L=50e-9 W='1*90e-9'
mn983 col<23> sel<5> 0 0 NMOS_VTL L=50e-9 W='1*90e-9'
mn984 col<24> sel<5> 0 0 NMOS_VTL L=50e-9 W='1*90e-9'
mn985 col<25> sel<5> 0 0 NMOS_VTL L=50e-9 W='1*90e-9'
mn986 col<26> sel<5> 0 0 NMOS_VTL L=50e-9 W='1*90e-9'
mn987 col<27> sel<5> 0 0 NMOS_VTL L=50e-9 W='1*90e-9'
mn988 col<28> sel<5> 0 0 NMOS_VTL L=50e-9 W='1*90e-9'
mn989 col<29> sel<5> 0 0 NMOS_VTL L=50e-9 W='1*90e-9'
mn993 col<33> sel<5> 0 0 NMOS_VTL L=50e-9 W='1*90e-9'
mn996 col<36> sel<5> 0 0 NMOS_VTL L=50e-9 W='1*90e-9'
mn999 col<39> sel<5> 0 0 NMOS_VTL L=50e-9 W='1*90e-9'
mn1002 col<42> sel<5> 0 0 NMOS_VTL L=50e-9 W='1*90e-9'
mn1003 col<43> sel<5> 0 0 NMOS_VTL L=50e-9 W='1*90e-9'
mn1004 col<44> sel<5> 0 0 NMOS_VTL L=50e-9 W='1*90e-9'
mn1005 col<45> sel<5> 0 0 NMOS_VTL L=50e-9 W='1*90e-9'
mn1006 col<46> sel<5> 0 0 NMOS_VTL L=50e-9 W='1*90e-9'
mn1007 col<47> sel<5> 0 0 NMOS_VTL L=50e-9 W='1*90e-9'
mn1011 col<51> sel<5> 0 0 NMOS_VTL L=50e-9 W='1*90e-9'
mn1012 col<52> sel<5> 0 0 NMOS_VTL L=50e-9 W='1*90e-9'
mn1013 col<53> sel<5> 0 0 NMOS_VTL L=50e-9 W='1*90e-9'
mn1017 col<57> sel<5> 0 0 NMOS_VTL L=50e-9 W='1*90e-9'
mn1020 col<60> sel<5> 0 0 NMOS_VTL L=50e-9 W='1*90e-9'
mn1021 col<61> sel<5> 0 0 NMOS_VTL L=50e-9 W='1*90e-9'
mn1022 col<62> sel<5> 0 0 NMOS_VTL L=50e-9 W='1*90e-9'
mn1023 col<63> sel<5> 0 0 NMOS_VTL L=50e-9 W='1*90e-9'
mn1024 col<64> sel<5> 0 0 NMOS_VTL L=50e-9 W='1*90e-9'
mn1025 col<65> sel<5> 0 0 NMOS_VTL L=50e-9 W='1*90e-9'
mn1029 col<69> sel<5> 0 0 NMOS_VTL L=50e-9 W='1*90e-9'
mn1030 col<70> sel<5> 0 0 NMOS_VTL L=50e-9 W='1*90e-9'
mn1031 col<71> sel<5> 0 0 NMOS_VTL L=50e-9 W='1*90e-9'
mn1032 col<72> sel<5> 0 0 NMOS_VTL L=50e-9 W='1*90e-9'
mn1033 col<73> sel<5> 0 0 NMOS_VTL L=50e-9 W='1*90e-9'
mn1034 col<74> sel<5> 0 0 NMOS_VTL L=50e-9 W='1*90e-9'
mn1035 col<75> sel<5> 0 0 NMOS_VTL L=50e-9 W='1*90e-9'
mn1036 col<76> sel<5> 0 0 NMOS_VTL L=50e-9 W='1*90e-9'
mn1037 col<77> sel<5> 0 0 NMOS_VTL L=50e-9 W='1*90e-9'
mn1038 col<78> sel<5> 0 0 NMOS_VTL L=50e-9 W='1*90e-9'
mn1042 col<82> sel<5> 0 0 NMOS_VTL L=50e-9 W='1*90e-9'
mn1044 col<84> sel<5> 0 0 NMOS_VTL L=50e-9 W='1*90e-9'
mn1046 col<86> sel<5> 0 0 NMOS_VTL L=50e-9 W='1*90e-9'
mn1048 col<88> sel<5> 0 0 NMOS_VTL L=50e-9 W='1*90e-9'
mn1049 col<89> sel<5> 0 0 NMOS_VTL L=50e-9 W='1*90e-9'
mn1050 col<90> sel<5> 0 0 NMOS_VTL L=50e-9 W='1*90e-9'
mn1051 col<91> sel<5> 0 0 NMOS_VTL L=50e-9 W='1*90e-9'
mn1052 col<92> sel<5> 0 0 NMOS_VTL L=50e-9 W='1*90e-9'
mn1053 col<93> sel<5> 0 0 NMOS_VTL L=50e-9 W='1*90e-9'
mn1054 col<94> sel<5> 0 0 NMOS_VTL L=50e-9 W='1*90e-9'
mn1055 col<95> sel<5> 0 0 NMOS_VTL L=50e-9 W='1*90e-9'
mn1056 col<96> sel<5> 0 0 NMOS_VTL L=50e-9 W='1*90e-9'
mn1057 col<97> sel<5> 0 0 NMOS_VTL L=50e-9 W='1*90e-9'
mn1058 col<98> sel<5> 0 0 NMOS_VTL L=50e-9 W='1*90e-9'
mn1062 col<102> sel<5> 0 0 NMOS_VTL L=50e-9 W='1*90e-9'
mn1066 col<106> sel<5> 0 0 NMOS_VTL L=50e-9 W='1*90e-9'
mn1068 col<108> sel<5> 0 0 NMOS_VTL L=50e-9 W='1*90e-9'
mn1069 col<109> sel<5> 0 0 NMOS_VTL L=50e-9 W='1*90e-9'
mn1070 col<110> sel<5> 0 0 NMOS_VTL L=50e-9 W='1*90e-9'
mn1071 col<111> sel<5> 0 0 NMOS_VTL L=50e-9 W='1*90e-9'
mn1072 col<112> sel<5> 0 0 NMOS_VTL L=50e-9 W='1*90e-9'
mn1073 col<113> sel<5> 0 0 NMOS_VTL L=50e-9 W='1*90e-9'
mn1074 col<114> sel<5> 0 0 NMOS_VTL L=50e-9 W='1*90e-9'
mn1077 col<117> sel<5> 0 0 NMOS_VTL L=50e-9 W='1*90e-9'
mn1078 col<118> sel<5> 0 0 NMOS_VTL L=50e-9 W='1*90e-9'
mn1079 col<119> sel<5> 0 0 NMOS_VTL L=50e-9 W='1*90e-9'
mn1080 col<120> sel<5> 0 0 NMOS_VTL L=50e-9 W='1*90e-9'
mn1081 col<121> sel<5> 0 0 NMOS_VTL L=50e-9 W='1*90e-9'
mn1082 col<122> sel<5> 0 0 NMOS_VTL L=50e-9 W='1*90e-9'
mn1086 col<126> sel<5> 0 0 NMOS_VTL L=50e-9 W='1*90e-9'
mn1087 col<127> sel<5> 0 0 NMOS_VTL L=50e-9 W='1*90e-9'
mn1089 col<129> sel<5> 0 0 NMOS_VTL L=50e-9 W='1*90e-9'
mn1090 col<130> sel<5> 0 0 NMOS_VTL L=50e-9 W='1*90e-9'
mn1092 col<132> sel<5> 0 0 NMOS_VTL L=50e-9 W='1*90e-9'
mn1096 col<136> sel<5> 0 0 NMOS_VTL L=50e-9 W='1*90e-9'
mn1098 col<138> sel<5> 0 0 NMOS_VTL L=50e-9 W='1*90e-9'
mn1101 col<141> sel<5> 0 0 NMOS_VTL L=50e-9 W='1*90e-9'
mn1102 col<142> sel<5> 0 0 NMOS_VTL L=50e-9 W='1*90e-9'
mn1103 col<143> sel<5> 0 0 NMOS_VTL L=50e-9 W='1*90e-9'
mn1104 col<144> sel<5> 0 0 NMOS_VTL L=50e-9 W='1*90e-9'
mn1105 col<145> sel<5> 0 0 NMOS_VTL L=50e-9 W='1*90e-9'
mn1106 col<146> sel<5> 0 0 NMOS_VTL L=50e-9 W='1*90e-9'
mn1122 col<162> sel<5> 0 0 NMOS_VTL L=50e-9 W='1*90e-9'
mn1123 col<163> sel<5> 0 0 NMOS_VTL L=50e-9 W='1*90e-9'
mn1124 col<164> sel<5> 0 0 NMOS_VTL L=50e-9 W='1*90e-9'
mn1125 col<165> sel<5> 0 0 NMOS_VTL L=50e-9 W='1*90e-9'
mn1126 col<166> sel<5> 0 0 NMOS_VTL L=50e-9 W='1*90e-9'
mn1127 col<167> sel<5> 0 0 NMOS_VTL L=50e-9 W='1*90e-9'
mn1128 col<168> sel<5> 0 0 NMOS_VTL L=50e-9 W='1*90e-9'
mn1129 col<169> sel<5> 0 0 NMOS_VTL L=50e-9 W='1*90e-9'
mn1130 col<170> sel<5> 0 0 NMOS_VTL L=50e-9 W='1*90e-9'
mn1131 col<171> sel<5> 0 0 NMOS_VTL L=50e-9 W='1*90e-9'
mn1132 col<172> sel<5> 0 0 NMOS_VTL L=50e-9 W='1*90e-9'
mn1133 col<173> sel<5> 0 0 NMOS_VTL L=50e-9 W='1*90e-9'
mn1135 col<175> sel<5> 0 0 NMOS_VTL L=50e-9 W='1*90e-9'
mn1136 col<176> sel<5> 0 0 NMOS_VTL L=50e-9 W='1*90e-9'
mn1137 col<177> sel<5> 0 0 NMOS_VTL L=50e-9 W='1*90e-9'
mn1138 col<178> sel<5> 0 0 NMOS_VTL L=50e-9 W='1*90e-9'
mn1139 col<179> sel<5> 0 0 NMOS_VTL L=50e-9 W='1*90e-9'
mn1140 col<180> sel<5> 0 0 NMOS_VTL L=50e-9 W='1*90e-9'
mn1141 col<181> sel<5> 0 0 NMOS_VTL L=50e-9 W='1*90e-9'
mn1142 col<182> sel<5> 0 0 NMOS_VTL L=50e-9 W='1*90e-9'
mn1144 col<184> sel<5> 0 0 NMOS_VTL L=50e-9 W='1*90e-9'
mn1145 col<185> sel<5> 0 0 NMOS_VTL L=50e-9 W='1*90e-9'
mn1146 col<186> sel<5> 0 0 NMOS_VTL L=50e-9 W='1*90e-9'
mn1147 col<187> sel<5> 0 0 NMOS_VTL L=50e-9 W='1*90e-9'
mn1148 col<188> sel<5> 0 0 NMOS_VTL L=50e-9 W='1*90e-9'
mn1149 col<189> sel<5> 0 0 NMOS_VTL L=50e-9 W='1*90e-9'
mn1150 col<190> sel<5> 0 0 NMOS_VTL L=50e-9 W='1*90e-9'
mn1151 col<191> sel<5> 0 0 NMOS_VTL L=50e-9 W='1*90e-9'
mn1161 col<9> sel<6> 0 0 NMOS_VTL L=50e-9 W='1*90e-9'
mn1162 col<10> sel<6> 0 0 NMOS_VTL L=50e-9 W='1*90e-9'
mn1163 col<11> sel<6> 0 0 NMOS_VTL L=50e-9 W='1*90e-9'
mn1164 col<12> sel<6> 0 0 NMOS_VTL L=50e-9 W='1*90e-9'
mn1165 col<13> sel<6> 0 0 NMOS_VTL L=50e-9 W='1*90e-9'
mn1166 col<14> sel<6> 0 0 NMOS_VTL L=50e-9 W='1*90e-9'
mn1167 col<15> sel<6> 0 0 NMOS_VTL L=50e-9 W='1*90e-9'
mn1168 col<16> sel<6> 0 0 NMOS_VTL L=50e-9 W='1*90e-9'
mn1169 col<17> sel<6> 0 0 NMOS_VTL L=50e-9 W='1*90e-9'
mn1170 col<18> sel<6> 0 0 NMOS_VTL L=50e-9 W='1*90e-9'
mn1171 col<19> sel<6> 0 0 NMOS_VTL L=50e-9 W='1*90e-9'
mn1172 col<20> sel<6> 0 0 NMOS_VTL L=50e-9 W='1*90e-9'
mn1173 col<21> sel<6> 0 0 NMOS_VTL L=50e-9 W='1*90e-9'
mn1174 col<22> sel<6> 0 0 NMOS_VTL L=50e-9 W='1*90e-9'
mn1175 col<23> sel<6> 0 0 NMOS_VTL L=50e-9 W='1*90e-9'
mn1185 col<33> sel<6> 0 0 NMOS_VTL L=50e-9 W='1*90e-9'
mn1186 col<34> sel<6> 0 0 NMOS_VTL L=50e-9 W='1*90e-9'
mn1187 col<35> sel<6> 0 0 NMOS_VTL L=50e-9 W='1*90e-9'
mn1188 col<36> sel<6> 0 0 NMOS_VTL L=50e-9 W='1*90e-9'
mn1189 col<37> sel<6> 0 0 NMOS_VTL L=50e-9 W='1*90e-9'
mn1190 col<38> sel<6> 0 0 NMOS_VTL L=50e-9 W='1*90e-9'
mn1191 col<39> sel<6> 0 0 NMOS_VTL L=50e-9 W='1*90e-9'
mn1192 col<40> sel<6> 0 0 NMOS_VTL L=50e-9 W='1*90e-9'
mn1193 col<41> sel<6> 0 0 NMOS_VTL L=50e-9 W='1*90e-9'
mn1194 col<42> sel<6> 0 0 NMOS_VTL L=50e-9 W='1*90e-9'
mn1195 col<43> sel<6> 0 0 NMOS_VTL L=50e-9 W='1*90e-9'
mn1196 col<44> sel<6> 0 0 NMOS_VTL L=50e-9 W='1*90e-9'
mn1200 col<48> sel<6> 0 0 NMOS_VTL L=50e-9 W='1*90e-9'
mn1201 col<49> sel<6> 0 0 NMOS_VTL L=50e-9 W='1*90e-9'
mn1202 col<50> sel<6> 0 0 NMOS_VTL L=50e-9 W='1*90e-9'
mn1209 col<57> sel<6> 0 0 NMOS_VTL L=50e-9 W='1*90e-9'
mn1210 col<58> sel<6> 0 0 NMOS_VTL L=50e-9 W='1*90e-9'
mn1211 col<59> sel<6> 0 0 NMOS_VTL L=50e-9 W='1*90e-9'
mn1212 col<60> sel<6> 0 0 NMOS_VTL L=50e-9 W='1*90e-9'
mn1213 col<61> sel<6> 0 0 NMOS_VTL L=50e-9 W='1*90e-9'
mn1214 col<62> sel<6> 0 0 NMOS_VTL L=50e-9 W='1*90e-9'
mn1215 col<63> sel<6> 0 0 NMOS_VTL L=50e-9 W='1*90e-9'
mn1218 col<66> sel<6> 0 0 NMOS_VTL L=50e-9 W='1*90e-9'
mn1219 col<67> sel<6> 0 0 NMOS_VTL L=50e-9 W='1*90e-9'
mn1220 col<68> sel<6> 0 0 NMOS_VTL L=50e-9 W='1*90e-9'
mn1224 col<72> sel<6> 0 0 NMOS_VTL L=50e-9 W='1*90e-9'
mn1225 col<73> sel<6> 0 0 NMOS_VTL L=50e-9 W='1*90e-9'
mn1226 col<74> sel<6> 0 0 NMOS_VTL L=50e-9 W='1*90e-9'
mn1234 col<82> sel<6> 0 0 NMOS_VTL L=50e-9 W='1*90e-9'
mn1235 col<83> sel<6> 0 0 NMOS_VTL L=50e-9 W='1*90e-9'
mn1236 col<84> sel<6> 0 0 NMOS_VTL L=50e-9 W='1*90e-9'
mn1237 col<85> sel<6> 0 0 NMOS_VTL L=50e-9 W='1*90e-9'
mn1238 col<86> sel<6> 0 0 NMOS_VTL L=50e-9 W='1*90e-9'
mn1239 col<87> sel<6> 0 0 NMOS_VTL L=50e-9 W='1*90e-9'
mn1243 col<91> sel<6> 0 0 NMOS_VTL L=50e-9 W='1*90e-9'
mn1244 col<92> sel<6> 0 0 NMOS_VTL L=50e-9 W='1*90e-9'
mn1245 col<93> sel<6> 0 0 NMOS_VTL L=50e-9 W='1*90e-9'
mn1246 col<94> sel<6> 0 0 NMOS_VTL L=50e-9 W='1*90e-9'
mn1247 col<95> sel<6> 0 0 NMOS_VTL L=50e-9 W='1*90e-9'
mn1248 col<96> sel<6> 0 0 NMOS_VTL L=50e-9 W='1*90e-9'
mn1249 col<97> sel<6> 0 0 NMOS_VTL L=50e-9 W='1*90e-9'
mn1250 col<98> sel<6> 0 0 NMOS_VTL L=50e-9 W='1*90e-9'
mn1255 col<103> sel<6> 0 0 NMOS_VTL L=50e-9 W='1*90e-9'
mn1260 col<108> sel<6> 0 0 NMOS_VTL L=50e-9 W='1*90e-9'
mn1261 col<109> sel<6> 0 0 NMOS_VTL L=50e-9 W='1*90e-9'
mn1263 col<111> sel<6> 0 0 NMOS_VTL L=50e-9 W='1*90e-9'
mn1266 col<114> sel<6> 0 0 NMOS_VTL L=50e-9 W='1*90e-9'
mn1267 col<115> sel<6> 0 0 NMOS_VTL L=50e-9 W='1*90e-9'
mn1268 col<116> sel<6> 0 0 NMOS_VTL L=50e-9 W='1*90e-9'
mn1278 col<126> sel<6> 0 0 NMOS_VTL L=50e-9 W='1*90e-9'
mn1279 col<127> sel<6> 0 0 NMOS_VTL L=50e-9 W='1*90e-9'
mn1280 col<128> sel<6> 0 0 NMOS_VTL L=50e-9 W='1*90e-9'
mn1281 col<129> sel<6> 0 0 NMOS_VTL L=50e-9 W='1*90e-9'
mn1282 col<130> sel<6> 0 0 NMOS_VTL L=50e-9 W='1*90e-9'
mn1283 col<131> sel<6> 0 0 NMOS_VTL L=50e-9 W='1*90e-9'
mn1284 col<132> sel<6> 0 0 NMOS_VTL L=50e-9 W='1*90e-9'
mn1293 col<141> sel<6> 0 0 NMOS_VTL L=50e-9 W='1*90e-9'
mn1294 col<142> sel<6> 0 0 NMOS_VTL L=50e-9 W='1*90e-9'
mn1295 col<143> sel<6> 0 0 NMOS_VTL L=50e-9 W='1*90e-9'
mn1296 col<144> sel<6> 0 0 NMOS_VTL L=50e-9 W='1*90e-9'
mn1297 col<145> sel<6> 0 0 NMOS_VTL L=50e-9 W='1*90e-9'
mn1298 col<146> sel<6> 0 0 NMOS_VTL L=50e-9 W='1*90e-9'
mn1299 col<147> sel<6> 0 0 NMOS_VTL L=50e-9 W='1*90e-9'
mn1300 col<148> sel<6> 0 0 NMOS_VTL L=50e-9 W='1*90e-9'
mn1301 col<149> sel<6> 0 0 NMOS_VTL L=50e-9 W='1*90e-9'
mn1302 col<150> sel<6> 0 0 NMOS_VTL L=50e-9 W='1*90e-9'
mn1303 col<151> sel<6> 0 0 NMOS_VTL L=50e-9 W='1*90e-9'
mn1304 col<152> sel<6> 0 0 NMOS_VTL L=50e-9 W='1*90e-9'
mn1306 col<154> sel<6> 0 0 NMOS_VTL L=50e-9 W='1*90e-9'
mn1307 col<155> sel<6> 0 0 NMOS_VTL L=50e-9 W='1*90e-9'
mn1309 col<157> sel<6> 0 0 NMOS_VTL L=50e-9 W='1*90e-9'
mn1310 col<158> sel<6> 0 0 NMOS_VTL L=50e-9 W='1*90e-9'
mn1317 col<165> sel<6> 0 0 NMOS_VTL L=50e-9 W='1*90e-9'
mn1318 col<166> sel<6> 0 0 NMOS_VTL L=50e-9 W='1*90e-9'
mn1319 col<167> sel<6> 0 0 NMOS_VTL L=50e-9 W='1*90e-9'
mn1320 col<168> sel<6> 0 0 NMOS_VTL L=50e-9 W='1*90e-9'
mn1321 col<169> sel<6> 0 0 NMOS_VTL L=50e-9 W='1*90e-9'
mn1322 col<170> sel<6> 0 0 NMOS_VTL L=50e-9 W='1*90e-9'
mn1326 col<174> sel<6> 0 0 NMOS_VTL L=50e-9 W='1*90e-9'
mn1327 col<175> sel<6> 0 0 NMOS_VTL L=50e-9 W='1*90e-9'
mn1328 col<176> sel<6> 0 0 NMOS_VTL L=50e-9 W='1*90e-9'
mn1329 col<177> sel<6> 0 0 NMOS_VTL L=50e-9 W='1*90e-9'
mn1330 col<178> sel<6> 0 0 NMOS_VTL L=50e-9 W='1*90e-9'
mn1331 col<179> sel<6> 0 0 NMOS_VTL L=50e-9 W='1*90e-9'
mn1335 col<183> sel<6> 0 0 NMOS_VTL L=50e-9 W='1*90e-9'
mn1336 col<184> sel<6> 0 0 NMOS_VTL L=50e-9 W='1*90e-9'
mn1337 col<185> sel<6> 0 0 NMOS_VTL L=50e-9 W='1*90e-9'
mn1338 col<186> sel<6> 0 0 NMOS_VTL L=50e-9 W='1*90e-9'
mn1339 col<187> sel<6> 0 0 NMOS_VTL L=50e-9 W='1*90e-9'
mn1340 col<188> sel<6> 0 0 NMOS_VTL L=50e-9 W='1*90e-9'
mn1341 col<189> sel<6> 0 0 NMOS_VTL L=50e-9 W='1*90e-9'
mn1342 col<190> sel<6> 0 0 NMOS_VTL L=50e-9 W='1*90e-9'
mn1343 col<191> sel<6> 0 0 NMOS_VTL L=50e-9 W='1*90e-9'
mn1344 col<0> sel<7> 0 0 NMOS_VTL L=50e-9 W='1*90e-9'
mn1345 col<1> sel<7> 0 0 NMOS_VTL L=50e-9 W='1*90e-9'
mn1346 col<2> sel<7> 0 0 NMOS_VTL L=50e-9 W='1*90e-9'
mn1347 col<3> sel<7> 0 0 NMOS_VTL L=50e-9 W='1*90e-9'
mn1348 col<4> sel<7> 0 0 NMOS_VTL L=50e-9 W='1*90e-9'
mn1349 col<5> sel<7> 0 0 NMOS_VTL L=50e-9 W='1*90e-9'
mn1353 col<9> sel<7> 0 0 NMOS_VTL L=50e-9 W='1*90e-9'
mn1354 col<10> sel<7> 0 0 NMOS_VTL L=50e-9 W='1*90e-9'
mn1355 col<11> sel<7> 0 0 NMOS_VTL L=50e-9 W='1*90e-9'
mn1356 col<12> sel<7> 0 0 NMOS_VTL L=50e-9 W='1*90e-9'
mn1357 col<13> sel<7> 0 0 NMOS_VTL L=50e-9 W='1*90e-9'
mn1358 col<14> sel<7> 0 0 NMOS_VTL L=50e-9 W='1*90e-9'
mn1359 col<15> sel<7> 0 0 NMOS_VTL L=50e-9 W='1*90e-9'
mn1360 col<16> sel<7> 0 0 NMOS_VTL L=50e-9 W='1*90e-9'
mn1361 col<17> sel<7> 0 0 NMOS_VTL L=50e-9 W='1*90e-9'
mn1365 col<21> sel<7> 0 0 NMOS_VTL L=50e-9 W='1*90e-9'
mn1366 col<22> sel<7> 0 0 NMOS_VTL L=50e-9 W='1*90e-9'
mn1367 col<23> sel<7> 0 0 NMOS_VTL L=50e-9 W='1*90e-9'
mn1374 col<30> sel<7> 0 0 NMOS_VTL L=50e-9 W='1*90e-9'
mn1376 col<32> sel<7> 0 0 NMOS_VTL L=50e-9 W='1*90e-9'
mn1378 col<34> sel<7> 0 0 NMOS_VTL L=50e-9 W='1*90e-9'
mn1379 col<35> sel<7> 0 0 NMOS_VTL L=50e-9 W='1*90e-9'
mn1386 col<42> sel<7> 0 0 NMOS_VTL L=50e-9 W='1*90e-9'
mn1387 col<43> sel<7> 0 0 NMOS_VTL L=50e-9 W='1*90e-9'
mn1388 col<44> sel<7> 0 0 NMOS_VTL L=50e-9 W='1*90e-9'
mn1389 col<45> sel<7> 0 0 NMOS_VTL L=50e-9 W='1*90e-9'
mn1390 col<46> sel<7> 0 0 NMOS_VTL L=50e-9 W='1*90e-9'
mn1391 col<47> sel<7> 0 0 NMOS_VTL L=50e-9 W='1*90e-9'
mn1395 col<51> sel<7> 0 0 NMOS_VTL L=50e-9 W='1*90e-9'
mn1396 col<52> sel<7> 0 0 NMOS_VTL L=50e-9 W='1*90e-9'
mn1397 col<53> sel<7> 0 0 NMOS_VTL L=50e-9 W='1*90e-9'
mn1398 col<54> sel<7> 0 0 NMOS_VTL L=50e-9 W='1*90e-9'
mn1399 col<55> sel<7> 0 0 NMOS_VTL L=50e-9 W='1*90e-9'
mn1400 col<56> sel<7> 0 0 NMOS_VTL L=50e-9 W='1*90e-9'
mn1404 col<60> sel<7> 0 0 NMOS_VTL L=50e-9 W='1*90e-9'
mn1407 col<63> sel<7> 0 0 NMOS_VTL L=50e-9 W='1*90e-9'
mn1408 col<64> sel<7> 0 0 NMOS_VTL L=50e-9 W='1*90e-9'
mn1409 col<65> sel<7> 0 0 NMOS_VTL L=50e-9 W='1*90e-9'
mn1410 col<66> sel<7> 0 0 NMOS_VTL L=50e-9 W='1*90e-9'
mn1411 col<67> sel<7> 0 0 NMOS_VTL L=50e-9 W='1*90e-9'
mn1412 col<68> sel<7> 0 0 NMOS_VTL L=50e-9 W='1*90e-9'
mn1413 col<69> sel<7> 0 0 NMOS_VTL L=50e-9 W='1*90e-9'
mn1414 col<70> sel<7> 0 0 NMOS_VTL L=50e-9 W='1*90e-9'
mn1415 col<71> sel<7> 0 0 NMOS_VTL L=50e-9 W='1*90e-9'
mn1419 col<75> sel<7> 0 0 NMOS_VTL L=50e-9 W='1*90e-9'
mn1420 col<76> sel<7> 0 0 NMOS_VTL L=50e-9 W='1*90e-9'
mn1421 col<77> sel<7> 0 0 NMOS_VTL L=50e-9 W='1*90e-9'
mn1422 col<78> sel<7> 0 0 NMOS_VTL L=50e-9 W='1*90e-9'
mn1423 col<79> sel<7> 0 0 NMOS_VTL L=50e-9 W='1*90e-9'
mn1424 col<80> sel<7> 0 0 NMOS_VTL L=50e-9 W='1*90e-9'
mn1432 col<88> sel<7> 0 0 NMOS_VTL L=50e-9 W='1*90e-9'
mn1433 col<89> sel<7> 0 0 NMOS_VTL L=50e-9 W='1*90e-9'
mn1437 col<93> sel<7> 0 0 NMOS_VTL L=50e-9 W='1*90e-9'
mn1438 col<94> sel<7> 0 0 NMOS_VTL L=50e-9 W='1*90e-9'
mn1439 col<95> sel<7> 0 0 NMOS_VTL L=50e-9 W='1*90e-9'
mn1441 col<97> sel<7> 0 0 NMOS_VTL L=50e-9 W='1*90e-9'
mn1442 col<98> sel<7> 0 0 NMOS_VTL L=50e-9 W='1*90e-9'
mn1446 col<102> sel<7> 0 0 NMOS_VTL L=50e-9 W='1*90e-9'
mn1447 col<103> sel<7> 0 0 NMOS_VTL L=50e-9 W='1*90e-9'
mn1448 col<104> sel<7> 0 0 NMOS_VTL L=50e-9 W='1*90e-9'
mn1453 col<109> sel<7> 0 0 NMOS_VTL L=50e-9 W='1*90e-9'
mn1454 col<110> sel<7> 0 0 NMOS_VTL L=50e-9 W='1*90e-9'
mn1456 col<112> sel<7> 0 0 NMOS_VTL L=50e-9 W='1*90e-9'
mn1457 col<113> sel<7> 0 0 NMOS_VTL L=50e-9 W='1*90e-9'
mn1461 col<117> sel<7> 0 0 NMOS_VTL L=50e-9 W='1*90e-9'
mn1462 col<118> sel<7> 0 0 NMOS_VTL L=50e-9 W='1*90e-9'
mn1463 col<119> sel<7> 0 0 NMOS_VTL L=50e-9 W='1*90e-9'
mn1464 col<120> sel<7> 0 0 NMOS_VTL L=50e-9 W='1*90e-9'
mn1465 col<121> sel<7> 0 0 NMOS_VTL L=50e-9 W='1*90e-9'
mn1466 col<122> sel<7> 0 0 NMOS_VTL L=50e-9 W='1*90e-9'
mn1467 col<123> sel<7> 0 0 NMOS_VTL L=50e-9 W='1*90e-9'
mn1468 col<124> sel<7> 0 0 NMOS_VTL L=50e-9 W='1*90e-9'
mn1469 col<125> sel<7> 0 0 NMOS_VTL L=50e-9 W='1*90e-9'
mn1470 col<126> sel<7> 0 0 NMOS_VTL L=50e-9 W='1*90e-9'
mn1471 col<127> sel<7> 0 0 NMOS_VTL L=50e-9 W='1*90e-9'
mn1472 col<128> sel<7> 0 0 NMOS_VTL L=50e-9 W='1*90e-9'
mn1474 col<130> sel<7> 0 0 NMOS_VTL L=50e-9 W='1*90e-9'
mn1479 col<135> sel<7> 0 0 NMOS_VTL L=50e-9 W='1*90e-9'
mn1481 col<137> sel<7> 0 0 NMOS_VTL L=50e-9 W='1*90e-9'
mn1482 col<138> sel<7> 0 0 NMOS_VTL L=50e-9 W='1*90e-9'
mn1483 col<139> sel<7> 0 0 NMOS_VTL L=50e-9 W='1*90e-9'
mn1484 col<140> sel<7> 0 0 NMOS_VTL L=50e-9 W='1*90e-9'
mn1488 col<144> sel<7> 0 0 NMOS_VTL L=50e-9 W='1*90e-9'
mn1489 col<145> sel<7> 0 0 NMOS_VTL L=50e-9 W='1*90e-9'
mn1490 col<146> sel<7> 0 0 NMOS_VTL L=50e-9 W='1*90e-9'
mn1491 col<147> sel<7> 0 0 NMOS_VTL L=50e-9 W='1*90e-9'
mn1492 col<148> sel<7> 0 0 NMOS_VTL L=50e-9 W='1*90e-9'
mn1493 col<149> sel<7> 0 0 NMOS_VTL L=50e-9 W='1*90e-9'
mn1503 col<159> sel<7> 0 0 NMOS_VTL L=50e-9 W='1*90e-9'
mn1504 col<160> sel<7> 0 0 NMOS_VTL L=50e-9 W='1*90e-9'
mn1505 col<161> sel<7> 0 0 NMOS_VTL L=50e-9 W='1*90e-9'
mn1506 col<162> sel<7> 0 0 NMOS_VTL L=50e-9 W='1*90e-9'
mn1507 col<163> sel<7> 0 0 NMOS_VTL L=50e-9 W='1*90e-9'
mn1508 col<164> sel<7> 0 0 NMOS_VTL L=50e-9 W='1*90e-9'
mn1513 col<169> sel<7> 0 0 NMOS_VTL L=50e-9 W='1*90e-9'
mn1514 col<170> sel<7> 0 0 NMOS_VTL L=50e-9 W='1*90e-9'
mn1515 col<171> sel<7> 0 0 NMOS_VTL L=50e-9 W='1*90e-9'
mn1516 col<172> sel<7> 0 0 NMOS_VTL L=50e-9 W='1*90e-9'
mn1517 col<173> sel<7> 0 0 NMOS_VTL L=50e-9 W='1*90e-9'
mn1519 col<175> sel<7> 0 0 NMOS_VTL L=50e-9 W='1*90e-9'
mn1520 col<176> sel<7> 0 0 NMOS_VTL L=50e-9 W='1*90e-9'
mn1521 col<177> sel<7> 0 0 NMOS_VTL L=50e-9 W='1*90e-9'
mn1522 col<178> sel<7> 0 0 NMOS_VTL L=50e-9 W='1*90e-9'
mn1523 col<179> sel<7> 0 0 NMOS_VTL L=50e-9 W='1*90e-9'
mn1525 col<181> sel<7> 0 0 NMOS_VTL L=50e-9 W='1*90e-9'
mn1526 col<182> sel<7> 0 0 NMOS_VTL L=50e-9 W='1*90e-9'
mn1527 col<183> sel<7> 0 0 NMOS_VTL L=50e-9 W='1*90e-9'
mn1528 col<184> sel<7> 0 0 NMOS_VTL L=50e-9 W='1*90e-9'
mn1529 col<185> sel<7> 0 0 NMOS_VTL L=50e-9 W='1*90e-9'
mn1530 col<186> sel<7> 0 0 NMOS_VTL L=50e-9 W='1*90e-9'
mn1531 col<187> sel<7> 0 0 NMOS_VTL L=50e-9 W='1*90e-9'
mn1532 col<188> sel<7> 0 0 NMOS_VTL L=50e-9 W='1*90e-9'
mn1533 col<189> sel<7> 0 0 NMOS_VTL L=50e-9 W='1*90e-9'
mn1534 col<190> sel<7> 0 0 NMOS_VTL L=50e-9 W='1*90e-9'
mn1535 col<191> sel<7> 0 0 NMOS_VTL L=50e-9 W='1*90e-9'
mn1539 col<3> sel<8> 0 0 NMOS_VTL L=50e-9 W='1*90e-9'
mn1540 col<4> sel<8> 0 0 NMOS_VTL L=50e-9 W='1*90e-9'
mn1541 col<5> sel<8> 0 0 NMOS_VTL L=50e-9 W='1*90e-9'
mn1542 col<6> sel<8> 0 0 NMOS_VTL L=50e-9 W='1*90e-9'
mn1543 col<7> sel<8> 0 0 NMOS_VTL L=50e-9 W='1*90e-9'
mn1544 col<8> sel<8> 0 0 NMOS_VTL L=50e-9 W='1*90e-9'
mn1551 col<15> sel<8> 0 0 NMOS_VTL L=50e-9 W='1*90e-9'
mn1552 col<16> sel<8> 0 0 NMOS_VTL L=50e-9 W='1*90e-9'
mn1553 col<17> sel<8> 0 0 NMOS_VTL L=50e-9 W='1*90e-9'
mn1554 col<18> sel<8> 0 0 NMOS_VTL L=50e-9 W='1*90e-9'
mn1555 col<19> sel<8> 0 0 NMOS_VTL L=50e-9 W='1*90e-9'
mn1556 col<20> sel<8> 0 0 NMOS_VTL L=50e-9 W='1*90e-9'
mn1563 col<27> sel<8> 0 0 NMOS_VTL L=50e-9 W='1*90e-9'
mn1564 col<28> sel<8> 0 0 NMOS_VTL L=50e-9 W='1*90e-9'
mn1565 col<29> sel<8> 0 0 NMOS_VTL L=50e-9 W='1*90e-9'
mn1566 col<30> sel<8> 0 0 NMOS_VTL L=50e-9 W='1*90e-9'
mn1567 col<31> sel<8> 0 0 NMOS_VTL L=50e-9 W='1*90e-9'
mn1568 col<32> sel<8> 0 0 NMOS_VTL L=50e-9 W='1*90e-9'
mn1579 col<43> sel<8> 0 0 NMOS_VTL L=50e-9 W='1*90e-9'
mn1580 col<44> sel<8> 0 0 NMOS_VTL L=50e-9 W='1*90e-9'
mn1584 col<48> sel<8> 0 0 NMOS_VTL L=50e-9 W='1*90e-9'
mn1585 col<49> sel<8> 0 0 NMOS_VTL L=50e-9 W='1*90e-9'
mn1586 col<50> sel<8> 0 0 NMOS_VTL L=50e-9 W='1*90e-9'
mn1596 col<60> sel<8> 0 0 NMOS_VTL L=50e-9 W='1*90e-9'
mn1600 col<64> sel<8> 0 0 NMOS_VTL L=50e-9 W='1*90e-9'
mn1601 col<65> sel<8> 0 0 NMOS_VTL L=50e-9 W='1*90e-9'
mn1603 col<67> sel<8> 0 0 NMOS_VTL L=50e-9 W='1*90e-9'
mn1604 col<68> sel<8> 0 0 NMOS_VTL L=50e-9 W='1*90e-9'
mn1606 col<70> sel<8> 0 0 NMOS_VTL L=50e-9 W='1*90e-9'
mn1607 col<71> sel<8> 0 0 NMOS_VTL L=50e-9 W='1*90e-9'
mn1608 col<72> sel<8> 0 0 NMOS_VTL L=50e-9 W='1*90e-9'
mn1609 col<73> sel<8> 0 0 NMOS_VTL L=50e-9 W='1*90e-9'
mn1610 col<74> sel<8> 0 0 NMOS_VTL L=50e-9 W='1*90e-9'
mn1611 col<75> sel<8> 0 0 NMOS_VTL L=50e-9 W='1*90e-9'
mn1612 col<76> sel<8> 0 0 NMOS_VTL L=50e-9 W='1*90e-9'
mn1613 col<77> sel<8> 0 0 NMOS_VTL L=50e-9 W='1*90e-9'
mn1614 col<78> sel<8> 0 0 NMOS_VTL L=50e-9 W='1*90e-9'
mn1615 col<79> sel<8> 0 0 NMOS_VTL L=50e-9 W='1*90e-9'
mn1616 col<80> sel<8> 0 0 NMOS_VTL L=50e-9 W='1*90e-9'
mn1617 col<81> sel<8> 0 0 NMOS_VTL L=50e-9 W='1*90e-9'
mn1619 col<83> sel<8> 0 0 NMOS_VTL L=50e-9 W='1*90e-9'
mn1620 col<84> sel<8> 0 0 NMOS_VTL L=50e-9 W='1*90e-9'
mn1621 col<85> sel<8> 0 0 NMOS_VTL L=50e-9 W='1*90e-9'
mn1622 col<86> sel<8> 0 0 NMOS_VTL L=50e-9 W='1*90e-9'
mn1626 col<90> sel<8> 0 0 NMOS_VTL L=50e-9 W='1*90e-9'
mn1627 col<91> sel<8> 0 0 NMOS_VTL L=50e-9 W='1*90e-9'
mn1628 col<92> sel<8> 0 0 NMOS_VTL L=50e-9 W='1*90e-9'
mn1629 col<93> sel<8> 0 0 NMOS_VTL L=50e-9 W='1*90e-9'
mn1630 col<94> sel<8> 0 0 NMOS_VTL L=50e-9 W='1*90e-9'
mn1631 col<95> sel<8> 0 0 NMOS_VTL L=50e-9 W='1*90e-9'
mn1632 col<96> sel<8> 0 0 NMOS_VTL L=50e-9 W='1*90e-9'
mn1633 col<97> sel<8> 0 0 NMOS_VTL L=50e-9 W='1*90e-9'
mn1634 col<98> sel<8> 0 0 NMOS_VTL L=50e-9 W='1*90e-9'
mn1635 col<99> sel<8> 0 0 NMOS_VTL L=50e-9 W='1*90e-9'
mn1636 col<100> sel<8> 0 0 NMOS_VTL L=50e-9 W='1*90e-9'
mn1637 col<101> sel<8> 0 0 NMOS_VTL L=50e-9 W='1*90e-9'
mn1638 col<102> sel<8> 0 0 NMOS_VTL L=50e-9 W='1*90e-9'
mn1639 col<103> sel<8> 0 0 NMOS_VTL L=50e-9 W='1*90e-9'
mn1640 col<104> sel<8> 0 0 NMOS_VTL L=50e-9 W='1*90e-9'
mn1644 col<108> sel<8> 0 0 NMOS_VTL L=50e-9 W='1*90e-9'
mn1647 col<111> sel<8> 0 0 NMOS_VTL L=50e-9 W='1*90e-9'
mn1648 col<112> sel<8> 0 0 NMOS_VTL L=50e-9 W='1*90e-9'
mn1649 col<113> sel<8> 0 0 NMOS_VTL L=50e-9 W='1*90e-9'
mn1650 col<114> sel<8> 0 0 NMOS_VTL L=50e-9 W='1*90e-9'
mn1651 col<115> sel<8> 0 0 NMOS_VTL L=50e-9 W='1*90e-9'
mn1652 col<116> sel<8> 0 0 NMOS_VTL L=50e-9 W='1*90e-9'
mn1656 col<120> sel<8> 0 0 NMOS_VTL L=50e-9 W='1*90e-9'
mn1657 col<121> sel<8> 0 0 NMOS_VTL L=50e-9 W='1*90e-9'
mn1658 col<122> sel<8> 0 0 NMOS_VTL L=50e-9 W='1*90e-9'
mn1660 col<124> sel<8> 0 0 NMOS_VTL L=50e-9 W='1*90e-9'
mn1661 col<125> sel<8> 0 0 NMOS_VTL L=50e-9 W='1*90e-9'
mn1662 col<126> sel<8> 0 0 NMOS_VTL L=50e-9 W='1*90e-9'
mn1666 col<130> sel<8> 0 0 NMOS_VTL L=50e-9 W='1*90e-9'
mn1671 col<135> sel<8> 0 0 NMOS_VTL L=50e-9 W='1*90e-9'
mn1672 col<136> sel<8> 0 0 NMOS_VTL L=50e-9 W='1*90e-9'
mn1673 col<137> sel<8> 0 0 NMOS_VTL L=50e-9 W='1*90e-9'
mn1680 col<144> sel<8> 0 0 NMOS_VTL L=50e-9 W='1*90e-9'
mn1681 col<145> sel<8> 0 0 NMOS_VTL L=50e-9 W='1*90e-9'
mn1682 col<146> sel<8> 0 0 NMOS_VTL L=50e-9 W='1*90e-9'
mn1686 col<150> sel<8> 0 0 NMOS_VTL L=50e-9 W='1*90e-9'
mn1687 col<151> sel<8> 0 0 NMOS_VTL L=50e-9 W='1*90e-9'
mn1688 col<152> sel<8> 0 0 NMOS_VTL L=50e-9 W='1*90e-9'
mn1689 col<153> sel<8> 0 0 NMOS_VTL L=50e-9 W='1*90e-9'
mn1690 col<154> sel<8> 0 0 NMOS_VTL L=50e-9 W='1*90e-9'
mn1691 col<155> sel<8> 0 0 NMOS_VTL L=50e-9 W='1*90e-9'
mn1693 col<157> sel<8> 0 0 NMOS_VTL L=50e-9 W='1*90e-9'
mn1694 col<158> sel<8> 0 0 NMOS_VTL L=50e-9 W='1*90e-9'
mn1695 col<159> sel<8> 0 0 NMOS_VTL L=50e-9 W='1*90e-9'
mn1696 col<160> sel<8> 0 0 NMOS_VTL L=50e-9 W='1*90e-9'
mn1697 col<161> sel<8> 0 0 NMOS_VTL L=50e-9 W='1*90e-9'
mn1701 col<165> sel<8> 0 0 NMOS_VTL L=50e-9 W='1*90e-9'
mn1702 col<166> sel<8> 0 0 NMOS_VTL L=50e-9 W='1*90e-9'
mn1703 col<167> sel<8> 0 0 NMOS_VTL L=50e-9 W='1*90e-9'
mn1716 col<180> sel<8> 0 0 NMOS_VTL L=50e-9 W='1*90e-9'
mn1717 col<181> sel<8> 0 0 NMOS_VTL L=50e-9 W='1*90e-9'
mn1718 col<182> sel<8> 0 0 NMOS_VTL L=50e-9 W='1*90e-9'
mn1719 col<183> sel<8> 0 0 NMOS_VTL L=50e-9 W='1*90e-9'
mn1720 col<184> sel<8> 0 0 NMOS_VTL L=50e-9 W='1*90e-9'
mn1721 col<185> sel<8> 0 0 NMOS_VTL L=50e-9 W='1*90e-9'
mn1722 col<186> sel<8> 0 0 NMOS_VTL L=50e-9 W='1*90e-9'
mn1723 col<187> sel<8> 0 0 NMOS_VTL L=50e-9 W='1*90e-9'
mn1724 col<188> sel<8> 0 0 NMOS_VTL L=50e-9 W='1*90e-9'
mn1725 col<189> sel<8> 0 0 NMOS_VTL L=50e-9 W='1*90e-9'
mn1726 col<190> sel<8> 0 0 NMOS_VTL L=50e-9 W='1*90e-9'
mn1727 col<191> sel<8> 0 0 NMOS_VTL L=50e-9 W='1*90e-9'
mn1728 col<0> sel<9> 0 0 NMOS_VTL L=50e-9 W='1*90e-9'
mn1729 col<1> sel<9> 0 0 NMOS_VTL L=50e-9 W='1*90e-9'
mn1730 col<2> sel<9> 0 0 NMOS_VTL L=50e-9 W='1*90e-9'
mn1737 col<9> sel<9> 0 0 NMOS_VTL L=50e-9 W='1*90e-9'
mn1738 col<10> sel<9> 0 0 NMOS_VTL L=50e-9 W='1*90e-9'
mn1739 col<11> sel<9> 0 0 NMOS_VTL L=50e-9 W='1*90e-9'
mn1740 col<12> sel<9> 0 0 NMOS_VTL L=50e-9 W='1*90e-9'
mn1741 col<13> sel<9> 0 0 NMOS_VTL L=50e-9 W='1*90e-9'
mn1742 col<14> sel<9> 0 0 NMOS_VTL L=50e-9 W='1*90e-9'
mn1746 col<18> sel<9> 0 0 NMOS_VTL L=50e-9 W='1*90e-9'
mn1747 col<19> sel<9> 0 0 NMOS_VTL L=50e-9 W='1*90e-9'
mn1748 col<20> sel<9> 0 0 NMOS_VTL L=50e-9 W='1*90e-9'
mn1752 col<24> sel<9> 0 0 NMOS_VTL L=50e-9 W='1*90e-9'
mn1753 col<25> sel<9> 0 0 NMOS_VTL L=50e-9 W='1*90e-9'
mn1754 col<26> sel<9> 0 0 NMOS_VTL L=50e-9 W='1*90e-9'
mn1764 col<36> sel<9> 0 0 NMOS_VTL L=50e-9 W='1*90e-9'
mn1765 col<37> sel<9> 0 0 NMOS_VTL L=50e-9 W='1*90e-9'
mn1766 col<38> sel<9> 0 0 NMOS_VTL L=50e-9 W='1*90e-9'
mn1767 col<39> sel<9> 0 0 NMOS_VTL L=50e-9 W='1*90e-9'
mn1768 col<40> sel<9> 0 0 NMOS_VTL L=50e-9 W='1*90e-9'
mn1769 col<41> sel<9> 0 0 NMOS_VTL L=50e-9 W='1*90e-9'
mn1770 col<42> sel<9> 0 0 NMOS_VTL L=50e-9 W='1*90e-9'
mn1771 col<43> sel<9> 0 0 NMOS_VTL L=50e-9 W='1*90e-9'
mn1772 col<44> sel<9> 0 0 NMOS_VTL L=50e-9 W='1*90e-9'
mn1773 col<45> sel<9> 0 0 NMOS_VTL L=50e-9 W='1*90e-9'
mn1774 col<46> sel<9> 0 0 NMOS_VTL L=50e-9 W='1*90e-9'
mn1775 col<47> sel<9> 0 0 NMOS_VTL L=50e-9 W='1*90e-9'
mn1776 col<48> sel<9> 0 0 NMOS_VTL L=50e-9 W='1*90e-9'
mn1777 col<49> sel<9> 0 0 NMOS_VTL L=50e-9 W='1*90e-9'
mn1778 col<50> sel<9> 0 0 NMOS_VTL L=50e-9 W='1*90e-9'
mn1785 col<57> sel<9> 0 0 NMOS_VTL L=50e-9 W='1*90e-9'
mn1788 col<60> sel<9> 0 0 NMOS_VTL L=50e-9 W='1*90e-9'
mn1791 col<63> sel<9> 0 0 NMOS_VTL L=50e-9 W='1*90e-9'
mn1792 col<64> sel<9> 0 0 NMOS_VTL L=50e-9 W='1*90e-9'
mn1793 col<65> sel<9> 0 0 NMOS_VTL L=50e-9 W='1*90e-9'
mn1794 col<66> sel<9> 0 0 NMOS_VTL L=50e-9 W='1*90e-9'
mn1795 col<67> sel<9> 0 0 NMOS_VTL L=50e-9 W='1*90e-9'
mn1796 col<68> sel<9> 0 0 NMOS_VTL L=50e-9 W='1*90e-9'
mn1803 col<75> sel<9> 0 0 NMOS_VTL L=50e-9 W='1*90e-9'
mn1804 col<76> sel<9> 0 0 NMOS_VTL L=50e-9 W='1*90e-9'
mn1805 col<77> sel<9> 0 0 NMOS_VTL L=50e-9 W='1*90e-9'
mn1812 col<84> sel<9> 0 0 NMOS_VTL L=50e-9 W='1*90e-9'
mn1828 col<100> sel<9> 0 0 NMOS_VTL L=50e-9 W='1*90e-9'
mn1829 col<101> sel<9> 0 0 NMOS_VTL L=50e-9 W='1*90e-9'
mn1830 col<102> sel<9> 0 0 NMOS_VTL L=50e-9 W='1*90e-9'
mn1831 col<103> sel<9> 0 0 NMOS_VTL L=50e-9 W='1*90e-9'
mn1832 col<104> sel<9> 0 0 NMOS_VTL L=50e-9 W='1*90e-9'
mn1833 col<105> sel<9> 0 0 NMOS_VTL L=50e-9 W='1*90e-9'
mn1834 col<106> sel<9> 0 0 NMOS_VTL L=50e-9 W='1*90e-9'
mn1835 col<107> sel<9> 0 0 NMOS_VTL L=50e-9 W='1*90e-9'
mn1836 col<108> sel<9> 0 0 NMOS_VTL L=50e-9 W='1*90e-9'
mn1843 col<115> sel<9> 0 0 NMOS_VTL L=50e-9 W='1*90e-9'
mn1844 col<116> sel<9> 0 0 NMOS_VTL L=50e-9 W='1*90e-9'
mn1848 col<120> sel<9> 0 0 NMOS_VTL L=50e-9 W='1*90e-9'
mn1849 col<121> sel<9> 0 0 NMOS_VTL L=50e-9 W='1*90e-9'
mn1850 col<122> sel<9> 0 0 NMOS_VTL L=50e-9 W='1*90e-9'
mn1854 col<126> sel<9> 0 0 NMOS_VTL L=50e-9 W='1*90e-9'
mn1855 col<127> sel<9> 0 0 NMOS_VTL L=50e-9 W='1*90e-9'
mn1856 col<128> sel<9> 0 0 NMOS_VTL L=50e-9 W='1*90e-9'
mn1857 col<129> sel<9> 0 0 NMOS_VTL L=50e-9 W='1*90e-9'
mn1858 col<130> sel<9> 0 0 NMOS_VTL L=50e-9 W='1*90e-9'
mn1859 col<131> sel<9> 0 0 NMOS_VTL L=50e-9 W='1*90e-9'
mn1860 col<132> sel<9> 0 0 NMOS_VTL L=50e-9 W='1*90e-9'
mn1861 col<133> sel<9> 0 0 NMOS_VTL L=50e-9 W='1*90e-9'
mn1862 col<134> sel<9> 0 0 NMOS_VTL L=50e-9 W='1*90e-9'
mn1869 col<141> sel<9> 0 0 NMOS_VTL L=50e-9 W='1*90e-9'
mn1870 col<142> sel<9> 0 0 NMOS_VTL L=50e-9 W='1*90e-9'
mn1871 col<143> sel<9> 0 0 NMOS_VTL L=50e-9 W='1*90e-9'
mn1881 col<153> sel<9> 0 0 NMOS_VTL L=50e-9 W='1*90e-9'
mn1890 col<162> sel<9> 0 0 NMOS_VTL L=50e-9 W='1*90e-9'
mn1891 col<163> sel<9> 0 0 NMOS_VTL L=50e-9 W='1*90e-9'
mn1892 col<164> sel<9> 0 0 NMOS_VTL L=50e-9 W='1*90e-9'
mn1893 col<165> sel<9> 0 0 NMOS_VTL L=50e-9 W='1*90e-9'
mn1894 col<166> sel<9> 0 0 NMOS_VTL L=50e-9 W='1*90e-9'
mn1895 col<167> sel<9> 0 0 NMOS_VTL L=50e-9 W='1*90e-9'
mn1896 col<168> sel<9> 0 0 NMOS_VTL L=50e-9 W='1*90e-9'
mn1897 col<169> sel<9> 0 0 NMOS_VTL L=50e-9 W='1*90e-9'
mn1898 col<170> sel<9> 0 0 NMOS_VTL L=50e-9 W='1*90e-9'
mn1899 col<171> sel<9> 0 0 NMOS_VTL L=50e-9 W='1*90e-9'
mn1900 col<172> sel<9> 0 0 NMOS_VTL L=50e-9 W='1*90e-9'
mn1901 col<173> sel<9> 0 0 NMOS_VTL L=50e-9 W='1*90e-9'
mn1911 col<183> sel<9> 0 0 NMOS_VTL L=50e-9 W='1*90e-9'
mn1912 col<184> sel<9> 0 0 NMOS_VTL L=50e-9 W='1*90e-9'
mn1913 col<185> sel<9> 0 0 NMOS_VTL L=50e-9 W='1*90e-9'
mn1914 col<186> sel<9> 0 0 NMOS_VTL L=50e-9 W='1*90e-9'
mn1915 col<187> sel<9> 0 0 NMOS_VTL L=50e-9 W='1*90e-9'
mn1916 col<188> sel<9> 0 0 NMOS_VTL L=50e-9 W='1*90e-9'
mn1917 col<189> sel<9> 0 0 NMOS_VTL L=50e-9 W='1*90e-9'
mn1918 col<190> sel<9> 0 0 NMOS_VTL L=50e-9 W='1*90e-9'
mn1919 col<191> sel<9> 0 0 NMOS_VTL L=50e-9 W='1*90e-9'
mn1923 col<3> sel<10> 0 0 NMOS_VTL L=50e-9 W='1*90e-9'
mn1924 col<4> sel<10> 0 0 NMOS_VTL L=50e-9 W='1*90e-9'
mn1925 col<5> sel<10> 0 0 NMOS_VTL L=50e-9 W='1*90e-9'
mn1926 col<6> sel<10> 0 0 NMOS_VTL L=50e-9 W='1*90e-9'
mn1927 col<7> sel<10> 0 0 NMOS_VTL L=50e-9 W='1*90e-9'
mn1928 col<8> sel<10> 0 0 NMOS_VTL L=50e-9 W='1*90e-9'
mn1929 col<9> sel<10> 0 0 NMOS_VTL L=50e-9 W='1*90e-9'
mn1930 col<10> sel<10> 0 0 NMOS_VTL L=50e-9 W='1*90e-9'
mn1931 col<11> sel<10> 0 0 NMOS_VTL L=50e-9 W='1*90e-9'
mn1938 col<18> sel<10> 0 0 NMOS_VTL L=50e-9 W='1*90e-9'
mn1939 col<19> sel<10> 0 0 NMOS_VTL L=50e-9 W='1*90e-9'
mn1940 col<20> sel<10> 0 0 NMOS_VTL L=50e-9 W='1*90e-9'
mn1941 col<21> sel<10> 0 0 NMOS_VTL L=50e-9 W='1*90e-9'
mn1942 col<22> sel<10> 0 0 NMOS_VTL L=50e-9 W='1*90e-9'
mn1943 col<23> sel<10> 0 0 NMOS_VTL L=50e-9 W='1*90e-9'
mn1944 col<24> sel<10> 0 0 NMOS_VTL L=50e-9 W='1*90e-9'
mn1945 col<25> sel<10> 0 0 NMOS_VTL L=50e-9 W='1*90e-9'
mn1946 col<26> sel<10> 0 0 NMOS_VTL L=50e-9 W='1*90e-9'
mn1947 col<27> sel<10> 0 0 NMOS_VTL L=50e-9 W='1*90e-9'
mn1948 col<28> sel<10> 0 0 NMOS_VTL L=50e-9 W='1*90e-9'
mn1949 col<29> sel<10> 0 0 NMOS_VTL L=50e-9 W='1*90e-9'
mn1953 col<33> sel<10> 0 0 NMOS_VTL L=50e-9 W='1*90e-9'
mn1954 col<34> sel<10> 0 0 NMOS_VTL L=50e-9 W='1*90e-9'
mn1955 col<35> sel<10> 0 0 NMOS_VTL L=50e-9 W='1*90e-9'
mn1956 col<36> sel<10> 0 0 NMOS_VTL L=50e-9 W='1*90e-9'
mn1957 col<37> sel<10> 0 0 NMOS_VTL L=50e-9 W='1*90e-9'
mn1958 col<38> sel<10> 0 0 NMOS_VTL L=50e-9 W='1*90e-9'
mn1959 col<39> sel<10> 0 0 NMOS_VTL L=50e-9 W='1*90e-9'
mn1960 col<40> sel<10> 0 0 NMOS_VTL L=50e-9 W='1*90e-9'
mn1961 col<41> sel<10> 0 0 NMOS_VTL L=50e-9 W='1*90e-9'
mn1965 col<45> sel<10> 0 0 NMOS_VTL L=50e-9 W='1*90e-9'
mn1966 col<46> sel<10> 0 0 NMOS_VTL L=50e-9 W='1*90e-9'
mn1967 col<47> sel<10> 0 0 NMOS_VTL L=50e-9 W='1*90e-9'
mn1972 col<52> sel<10> 0 0 NMOS_VTL L=50e-9 W='1*90e-9'
mn1973 col<53> sel<10> 0 0 NMOS_VTL L=50e-9 W='1*90e-9'
mn1981 col<61> sel<10> 0 0 NMOS_VTL L=50e-9 W='1*90e-9'
mn1982 col<62> sel<10> 0 0 NMOS_VTL L=50e-9 W='1*90e-9'
mn1984 col<64> sel<10> 0 0 NMOS_VTL L=50e-9 W='1*90e-9'
mn1985 col<65> sel<10> 0 0 NMOS_VTL L=50e-9 W='1*90e-9'
mn1986 col<66> sel<10> 0 0 NMOS_VTL L=50e-9 W='1*90e-9'
mn1987 col<67> sel<10> 0 0 NMOS_VTL L=50e-9 W='1*90e-9'
mn1988 col<68> sel<10> 0 0 NMOS_VTL L=50e-9 W='1*90e-9'
mn1989 col<69> sel<10> 0 0 NMOS_VTL L=50e-9 W='1*90e-9'
mn1990 col<70> sel<10> 0 0 NMOS_VTL L=50e-9 W='1*90e-9'
mn1991 col<71> sel<10> 0 0 NMOS_VTL L=50e-9 W='1*90e-9'
mn1992 col<72> sel<10> 0 0 NMOS_VTL L=50e-9 W='1*90e-9'
mn1993 col<73> sel<10> 0 0 NMOS_VTL L=50e-9 W='1*90e-9'
mn1994 col<74> sel<10> 0 0 NMOS_VTL L=50e-9 W='1*90e-9'
mn1995 col<75> sel<10> 0 0 NMOS_VTL L=50e-9 W='1*90e-9'
mn1996 col<76> sel<10> 0 0 NMOS_VTL L=50e-9 W='1*90e-9'
mn1997 col<77> sel<10> 0 0 NMOS_VTL L=50e-9 W='1*90e-9'
mn2001 col<81> sel<10> 0 0 NMOS_VTL L=50e-9 W='1*90e-9'
mn2004 col<84> sel<10> 0 0 NMOS_VTL L=50e-9 W='1*90e-9'
mn2005 col<85> sel<10> 0 0 NMOS_VTL L=50e-9 W='1*90e-9'
mn2006 col<86> sel<10> 0 0 NMOS_VTL L=50e-9 W='1*90e-9'
mn2011 col<91> sel<10> 0 0 NMOS_VTL L=50e-9 W='1*90e-9'
mn2012 col<92> sel<10> 0 0 NMOS_VTL L=50e-9 W='1*90e-9'
mn2013 col<93> sel<10> 0 0 NMOS_VTL L=50e-9 W='1*90e-9'
mn2014 col<94> sel<10> 0 0 NMOS_VTL L=50e-9 W='1*90e-9'
mn2015 col<95> sel<10> 0 0 NMOS_VTL L=50e-9 W='1*90e-9'
mn2016 col<96> sel<10> 0 0 NMOS_VTL L=50e-9 W='1*90e-9'
mn2017 col<97> sel<10> 0 0 NMOS_VTL L=50e-9 W='1*90e-9'
mn2018 col<98> sel<10> 0 0 NMOS_VTL L=50e-9 W='1*90e-9'
mn2022 col<102> sel<10> 0 0 NMOS_VTL L=50e-9 W='1*90e-9'
mn2025 col<105> sel<10> 0 0 NMOS_VTL L=50e-9 W='1*90e-9'
mn2028 col<108> sel<10> 0 0 NMOS_VTL L=50e-9 W='1*90e-9'
mn2031 col<111> sel<10> 0 0 NMOS_VTL L=50e-9 W='1*90e-9'
mn2037 col<117> sel<10> 0 0 NMOS_VTL L=50e-9 W='1*90e-9'
mn2038 col<118> sel<10> 0 0 NMOS_VTL L=50e-9 W='1*90e-9'
mn2039 col<119> sel<10> 0 0 NMOS_VTL L=50e-9 W='1*90e-9'
mn2040 col<120> sel<10> 0 0 NMOS_VTL L=50e-9 W='1*90e-9'
mn2041 col<121> sel<10> 0 0 NMOS_VTL L=50e-9 W='1*90e-9'
mn2042 col<122> sel<10> 0 0 NMOS_VTL L=50e-9 W='1*90e-9'
mn2043 col<123> sel<10> 0 0 NMOS_VTL L=50e-9 W='1*90e-9'
mn2044 col<124> sel<10> 0 0 NMOS_VTL L=50e-9 W='1*90e-9'
mn2045 col<125> sel<10> 0 0 NMOS_VTL L=50e-9 W='1*90e-9'
mn2046 col<126> sel<10> 0 0 NMOS_VTL L=50e-9 W='1*90e-9'
mn2047 col<127> sel<10> 0 0 NMOS_VTL L=50e-9 W='1*90e-9'
mn2048 col<128> sel<10> 0 0 NMOS_VTL L=50e-9 W='1*90e-9'
mn2052 col<132> sel<10> 0 0 NMOS_VTL L=50e-9 W='1*90e-9'
mn2055 col<135> sel<10> 0 0 NMOS_VTL L=50e-9 W='1*90e-9'
mn2058 col<138> sel<10> 0 0 NMOS_VTL L=50e-9 W='1*90e-9'
mn2059 col<139> sel<10> 0 0 NMOS_VTL L=50e-9 W='1*90e-9'
mn2060 col<140> sel<10> 0 0 NMOS_VTL L=50e-9 W='1*90e-9'
mn2068 col<148> sel<10> 0 0 NMOS_VTL L=50e-9 W='1*90e-9'
mn2069 col<149> sel<10> 0 0 NMOS_VTL L=50e-9 W='1*90e-9'
mn2070 col<150> sel<10> 0 0 NMOS_VTL L=50e-9 W='1*90e-9'
mn2071 col<151> sel<10> 0 0 NMOS_VTL L=50e-9 W='1*90e-9'
mn2072 col<152> sel<10> 0 0 NMOS_VTL L=50e-9 W='1*90e-9'
mn2073 col<153> sel<10> 0 0 NMOS_VTL L=50e-9 W='1*90e-9'
mn2074 col<154> sel<10> 0 0 NMOS_VTL L=50e-9 W='1*90e-9'
mn2075 col<155> sel<10> 0 0 NMOS_VTL L=50e-9 W='1*90e-9'
mn2077 col<157> sel<10> 0 0 NMOS_VTL L=50e-9 W='1*90e-9'
mn2078 col<158> sel<10> 0 0 NMOS_VTL L=50e-9 W='1*90e-9'
mn2079 col<159> sel<10> 0 0 NMOS_VTL L=50e-9 W='1*90e-9'
mn2080 col<160> sel<10> 0 0 NMOS_VTL L=50e-9 W='1*90e-9'
mn2081 col<161> sel<10> 0 0 NMOS_VTL L=50e-9 W='1*90e-9'
mn2082 col<162> sel<10> 0 0 NMOS_VTL L=50e-9 W='1*90e-9'
mn2083 col<163> sel<10> 0 0 NMOS_VTL L=50e-9 W='1*90e-9'
mn2084 col<164> sel<10> 0 0 NMOS_VTL L=50e-9 W='1*90e-9'
mn2085 col<165> sel<10> 0 0 NMOS_VTL L=50e-9 W='1*90e-9'
mn2086 col<166> sel<10> 0 0 NMOS_VTL L=50e-9 W='1*90e-9'
mn2087 col<167> sel<10> 0 0 NMOS_VTL L=50e-9 W='1*90e-9'
mn2091 col<171> sel<10> 0 0 NMOS_VTL L=50e-9 W='1*90e-9'
mn2092 col<172> sel<10> 0 0 NMOS_VTL L=50e-9 W='1*90e-9'
mn2093 col<173> sel<10> 0 0 NMOS_VTL L=50e-9 W='1*90e-9'
mn2097 col<177> sel<10> 0 0 NMOS_VTL L=50e-9 W='1*90e-9'
mn2098 col<178> sel<10> 0 0 NMOS_VTL L=50e-9 W='1*90e-9'
mn2099 col<179> sel<10> 0 0 NMOS_VTL L=50e-9 W='1*90e-9'
mn2100 col<180> sel<10> 0 0 NMOS_VTL L=50e-9 W='1*90e-9'
mn2101 col<181> sel<10> 0 0 NMOS_VTL L=50e-9 W='1*90e-9'
mn2102 col<182> sel<10> 0 0 NMOS_VTL L=50e-9 W='1*90e-9'
mn2103 col<183> sel<10> 0 0 NMOS_VTL L=50e-9 W='1*90e-9'
mn2104 col<184> sel<10> 0 0 NMOS_VTL L=50e-9 W='1*90e-9'
mn2105 col<185> sel<10> 0 0 NMOS_VTL L=50e-9 W='1*90e-9'
mn2106 col<186> sel<10> 0 0 NMOS_VTL L=50e-9 W='1*90e-9'
mn2107 col<187> sel<10> 0 0 NMOS_VTL L=50e-9 W='1*90e-9'
mn2108 col<188> sel<10> 0 0 NMOS_VTL L=50e-9 W='1*90e-9'
mn2109 col<189> sel<10> 0 0 NMOS_VTL L=50e-9 W='1*90e-9'
mn2110 col<190> sel<10> 0 0 NMOS_VTL L=50e-9 W='1*90e-9'
mn2111 col<191> sel<10> 0 0 NMOS_VTL L=50e-9 W='1*90e-9'
mn2112 col<0> sel<11> 0 0 NMOS_VTL L=50e-9 W='1*90e-9'
mn2113 col<1> sel<11> 0 0 NMOS_VTL L=50e-9 W='1*90e-9'
mn2114 col<2> sel<11> 0 0 NMOS_VTL L=50e-9 W='1*90e-9'
mn2125 col<13> sel<11> 0 0 NMOS_VTL L=50e-9 W='1*90e-9'
mn2126 col<14> sel<11> 0 0 NMOS_VTL L=50e-9 W='1*90e-9'
mn2128 col<16> sel<11> 0 0 NMOS_VTL L=50e-9 W='1*90e-9'
mn2129 col<17> sel<11> 0 0 NMOS_VTL L=50e-9 W='1*90e-9'
mn2131 col<19> sel<11> 0 0 NMOS_VTL L=50e-9 W='1*90e-9'
mn2132 col<20> sel<11> 0 0 NMOS_VTL L=50e-9 W='1*90e-9'
mn2133 col<21> sel<11> 0 0 NMOS_VTL L=50e-9 W='1*90e-9'
mn2134 col<22> sel<11> 0 0 NMOS_VTL L=50e-9 W='1*90e-9'
mn2135 col<23> sel<11> 0 0 NMOS_VTL L=50e-9 W='1*90e-9'
mn2136 col<24> sel<11> 0 0 NMOS_VTL L=50e-9 W='1*90e-9'
mn2137 col<25> sel<11> 0 0 NMOS_VTL L=50e-9 W='1*90e-9'
mn2138 col<26> sel<11> 0 0 NMOS_VTL L=50e-9 W='1*90e-9'
mn2140 col<28> sel<11> 0 0 NMOS_VTL L=50e-9 W='1*90e-9'
mn2141 col<29> sel<11> 0 0 NMOS_VTL L=50e-9 W='1*90e-9'
mn2154 col<42> sel<11> 0 0 NMOS_VTL L=50e-9 W='1*90e-9'
mn2155 col<43> sel<11> 0 0 NMOS_VTL L=50e-9 W='1*90e-9'
mn2156 col<44> sel<11> 0 0 NMOS_VTL L=50e-9 W='1*90e-9'
mn2157 col<45> sel<11> 0 0 NMOS_VTL L=50e-9 W='1*90e-9'
mn2158 col<46> sel<11> 0 0 NMOS_VTL L=50e-9 W='1*90e-9'
mn2159 col<47> sel<11> 0 0 NMOS_VTL L=50e-9 W='1*90e-9'
mn2160 col<48> sel<11> 0 0 NMOS_VTL L=50e-9 W='1*90e-9'
mn2161 col<49> sel<11> 0 0 NMOS_VTL L=50e-9 W='1*90e-9'
mn2162 col<50> sel<11> 0 0 NMOS_VTL L=50e-9 W='1*90e-9'
mn2169 col<57> sel<11> 0 0 NMOS_VTL L=50e-9 W='1*90e-9'
mn2170 col<58> sel<11> 0 0 NMOS_VTL L=50e-9 W='1*90e-9'
mn2173 col<61> sel<11> 0 0 NMOS_VTL L=50e-9 W='1*90e-9'
mn2175 col<63> sel<11> 0 0 NMOS_VTL L=50e-9 W='1*90e-9'
mn2176 col<64> sel<11> 0 0 NMOS_VTL L=50e-9 W='1*90e-9'
mn2181 col<69> sel<11> 0 0 NMOS_VTL L=50e-9 W='1*90e-9'
mn2182 col<70> sel<11> 0 0 NMOS_VTL L=50e-9 W='1*90e-9'
mn2183 col<71> sel<11> 0 0 NMOS_VTL L=50e-9 W='1*90e-9'
mn2184 col<72> sel<11> 0 0 NMOS_VTL L=50e-9 W='1*90e-9'
mn2185 col<73> sel<11> 0 0 NMOS_VTL L=50e-9 W='1*90e-9'
mn2186 col<74> sel<11> 0 0 NMOS_VTL L=50e-9 W='1*90e-9'
mn2193 col<81> sel<11> 0 0 NMOS_VTL L=50e-9 W='1*90e-9'
mn2202 col<90> sel<11> 0 0 NMOS_VTL L=50e-9 W='1*90e-9'
mn2205 col<93> sel<11> 0 0 NMOS_VTL L=50e-9 W='1*90e-9'
mn2206 col<94> sel<11> 0 0 NMOS_VTL L=50e-9 W='1*90e-9'
mn2207 col<95> sel<11> 0 0 NMOS_VTL L=50e-9 W='1*90e-9'
mn2209 col<97> sel<11> 0 0 NMOS_VTL L=50e-9 W='1*90e-9'
mn2210 col<98> sel<11> 0 0 NMOS_VTL L=50e-9 W='1*90e-9'
mn2215 col<103> sel<11> 0 0 NMOS_VTL L=50e-9 W='1*90e-9'
mn2216 col<104> sel<11> 0 0 NMOS_VTL L=50e-9 W='1*90e-9'
mn2217 col<105> sel<11> 0 0 NMOS_VTL L=50e-9 W='1*90e-9'
mn2219 col<107> sel<11> 0 0 NMOS_VTL L=50e-9 W='1*90e-9'
mn2220 col<108> sel<11> 0 0 NMOS_VTL L=50e-9 W='1*90e-9'
mn2222 col<110> sel<11> 0 0 NMOS_VTL L=50e-9 W='1*90e-9'
mn2223 col<111> sel<11> 0 0 NMOS_VTL L=50e-9 W='1*90e-9'
mn2229 col<117> sel<11> 0 0 NMOS_VTL L=50e-9 W='1*90e-9'
mn2230 col<118> sel<11> 0 0 NMOS_VTL L=50e-9 W='1*90e-9'
mn2231 col<119> sel<11> 0 0 NMOS_VTL L=50e-9 W='1*90e-9'
mn2232 col<120> sel<11> 0 0 NMOS_VTL L=50e-9 W='1*90e-9'
mn2233 col<121> sel<11> 0 0 NMOS_VTL L=50e-9 W='1*90e-9'
mn2234 col<122> sel<11> 0 0 NMOS_VTL L=50e-9 W='1*90e-9'
mn2235 col<123> sel<11> 0 0 NMOS_VTL L=50e-9 W='1*90e-9'
mn2241 col<129> sel<11> 0 0 NMOS_VTL L=50e-9 W='1*90e-9'
mn2243 col<131> sel<11> 0 0 NMOS_VTL L=50e-9 W='1*90e-9'
mn2247 col<135> sel<11> 0 0 NMOS_VTL L=50e-9 W='1*90e-9'
mn2250 col<138> sel<11> 0 0 NMOS_VTL L=50e-9 W='1*90e-9'
mn2251 col<139> sel<11> 0 0 NMOS_VTL L=50e-9 W='1*90e-9'
mn2252 col<140> sel<11> 0 0 NMOS_VTL L=50e-9 W='1*90e-9'
mn2254 col<142> sel<11> 0 0 NMOS_VTL L=50e-9 W='1*90e-9'
mn2255 col<143> sel<11> 0 0 NMOS_VTL L=50e-9 W='1*90e-9'
mn2256 col<144> sel<11> 0 0 NMOS_VTL L=50e-9 W='1*90e-9'
mn2257 col<145> sel<11> 0 0 NMOS_VTL L=50e-9 W='1*90e-9'
mn2258 col<146> sel<11> 0 0 NMOS_VTL L=50e-9 W='1*90e-9'
mn2259 col<147> sel<11> 0 0 NMOS_VTL L=50e-9 W='1*90e-9'
mn2260 col<148> sel<11> 0 0 NMOS_VTL L=50e-9 W='1*90e-9'
mn2261 col<149> sel<11> 0 0 NMOS_VTL L=50e-9 W='1*90e-9'
mn2263 col<151> sel<11> 0 0 NMOS_VTL L=50e-9 W='1*90e-9'
mn2266 col<154> sel<11> 0 0 NMOS_VTL L=50e-9 W='1*90e-9'
mn2268 col<156> sel<11> 0 0 NMOS_VTL L=50e-9 W='1*90e-9'
mn2274 col<162> sel<11> 0 0 NMOS_VTL L=50e-9 W='1*90e-9'
mn2275 col<163> sel<11> 0 0 NMOS_VTL L=50e-9 W='1*90e-9'
mn2276 col<164> sel<11> 0 0 NMOS_VTL L=50e-9 W='1*90e-9'
mn2278 col<166> sel<11> 0 0 NMOS_VTL L=50e-9 W='1*90e-9'
mn2279 col<167> sel<11> 0 0 NMOS_VTL L=50e-9 W='1*90e-9'
mn2281 col<169> sel<11> 0 0 NMOS_VTL L=50e-9 W='1*90e-9'
mn2282 col<170> sel<11> 0 0 NMOS_VTL L=50e-9 W='1*90e-9'
mn2283 col<171> sel<11> 0 0 NMOS_VTL L=50e-9 W='1*90e-9'
mn2284 col<172> sel<11> 0 0 NMOS_VTL L=50e-9 W='1*90e-9'
mn2285 col<173> sel<11> 0 0 NMOS_VTL L=50e-9 W='1*90e-9'
mn2295 col<183> sel<11> 0 0 NMOS_VTL L=50e-9 W='1*90e-9'
mn2296 col<184> sel<11> 0 0 NMOS_VTL L=50e-9 W='1*90e-9'
mn2297 col<185> sel<11> 0 0 NMOS_VTL L=50e-9 W='1*90e-9'
mn2298 col<186> sel<11> 0 0 NMOS_VTL L=50e-9 W='1*90e-9'
mn2299 col<187> sel<11> 0 0 NMOS_VTL L=50e-9 W='1*90e-9'
mn2300 col<188> sel<11> 0 0 NMOS_VTL L=50e-9 W='1*90e-9'
mn2304 col<0> sel<12> 0 0 NMOS_VTL L=50e-9 W='1*90e-9'
mn2305 col<1> sel<12> 0 0 NMOS_VTL L=50e-9 W='1*90e-9'
mn2306 col<2> sel<12> 0 0 NMOS_VTL L=50e-9 W='1*90e-9'
mn2316 col<12> sel<12> 0 0 NMOS_VTL L=50e-9 W='1*90e-9'
mn2317 col<13> sel<12> 0 0 NMOS_VTL L=50e-9 W='1*90e-9'
mn2318 col<14> sel<12> 0 0 NMOS_VTL L=50e-9 W='1*90e-9'
mn2325 col<21> sel<12> 0 0 NMOS_VTL L=50e-9 W='1*90e-9'
mn2326 col<22> sel<12> 0 0 NMOS_VTL L=50e-9 W='1*90e-9'
mn2327 col<23> sel<12> 0 0 NMOS_VTL L=50e-9 W='1*90e-9'
mn2328 col<24> sel<12> 0 0 NMOS_VTL L=50e-9 W='1*90e-9'
mn2329 col<25> sel<12> 0 0 NMOS_VTL L=50e-9 W='1*90e-9'
mn2330 col<26> sel<12> 0 0 NMOS_VTL L=50e-9 W='1*90e-9'
mn2331 col<27> sel<12> 0 0 NMOS_VTL L=50e-9 W='1*90e-9'
mn2332 col<28> sel<12> 0 0 NMOS_VTL L=50e-9 W='1*90e-9'
mn2333 col<29> sel<12> 0 0 NMOS_VTL L=50e-9 W='1*90e-9'
mn2337 col<33> sel<12> 0 0 NMOS_VTL L=50e-9 W='1*90e-9'
mn2341 col<37> sel<12> 0 0 NMOS_VTL L=50e-9 W='1*90e-9'
mn2355 col<51> sel<12> 0 0 NMOS_VTL L=50e-9 W='1*90e-9'
mn2356 col<52> sel<12> 0 0 NMOS_VTL L=50e-9 W='1*90e-9'
mn2357 col<53> sel<12> 0 0 NMOS_VTL L=50e-9 W='1*90e-9'
mn2361 col<57> sel<12> 0 0 NMOS_VTL L=50e-9 W='1*90e-9'
mn2362 col<58> sel<12> 0 0 NMOS_VTL L=50e-9 W='1*90e-9'
mn2363 col<59> sel<12> 0 0 NMOS_VTL L=50e-9 W='1*90e-9'
mn2365 col<61> sel<12> 0 0 NMOS_VTL L=50e-9 W='1*90e-9'
mn2366 col<62> sel<12> 0 0 NMOS_VTL L=50e-9 W='1*90e-9'
mn2367 col<63> sel<12> 0 0 NMOS_VTL L=50e-9 W='1*90e-9'
mn2368 col<64> sel<12> 0 0 NMOS_VTL L=50e-9 W='1*90e-9'
mn2369 col<65> sel<12> 0 0 NMOS_VTL L=50e-9 W='1*90e-9'
mn2373 col<69> sel<12> 0 0 NMOS_VTL L=50e-9 W='1*90e-9'
mn2374 col<70> sel<12> 0 0 NMOS_VTL L=50e-9 W='1*90e-9'
mn2375 col<71> sel<12> 0 0 NMOS_VTL L=50e-9 W='1*90e-9'
mn2379 col<75> sel<12> 0 0 NMOS_VTL L=50e-9 W='1*90e-9'
mn2380 col<76> sel<12> 0 0 NMOS_VTL L=50e-9 W='1*90e-9'
mn2381 col<77> sel<12> 0 0 NMOS_VTL L=50e-9 W='1*90e-9'
mn2382 col<78> sel<12> 0 0 NMOS_VTL L=50e-9 W='1*90e-9'
mn2383 col<79> sel<12> 0 0 NMOS_VTL L=50e-9 W='1*90e-9'
mn2384 col<80> sel<12> 0 0 NMOS_VTL L=50e-9 W='1*90e-9'
mn2391 col<87> sel<12> 0 0 NMOS_VTL L=50e-9 W='1*90e-9'
mn2392 col<88> sel<12> 0 0 NMOS_VTL L=50e-9 W='1*90e-9'
mn2393 col<89> sel<12> 0 0 NMOS_VTL L=50e-9 W='1*90e-9'
mn2397 col<93> sel<12> 0 0 NMOS_VTL L=50e-9 W='1*90e-9'
mn2398 col<94> sel<12> 0 0 NMOS_VTL L=50e-9 W='1*90e-9'
mn2399 col<95> sel<12> 0 0 NMOS_VTL L=50e-9 W='1*90e-9'
mn2400 col<96> sel<12> 0 0 NMOS_VTL L=50e-9 W='1*90e-9'
mn2401 col<97> sel<12> 0 0 NMOS_VTL L=50e-9 W='1*90e-9'
mn2402 col<98> sel<12> 0 0 NMOS_VTL L=50e-9 W='1*90e-9'
mn2403 col<99> sel<12> 0 0 NMOS_VTL L=50e-9 W='1*90e-9'
mn2404 col<100> sel<12> 0 0 NMOS_VTL L=50e-9 W='1*90e-9'
mn2405 col<101> sel<12> 0 0 NMOS_VTL L=50e-9 W='1*90e-9'
mn2406 col<102> sel<12> 0 0 NMOS_VTL L=50e-9 W='1*90e-9'
mn2407 col<103> sel<12> 0 0 NMOS_VTL L=50e-9 W='1*90e-9'
mn2408 col<104> sel<12> 0 0 NMOS_VTL L=50e-9 W='1*90e-9'
mn2409 col<105> sel<12> 0 0 NMOS_VTL L=50e-9 W='1*90e-9'
mn2412 col<108> sel<12> 0 0 NMOS_VTL L=50e-9 W='1*90e-9'
mn2413 col<109> sel<12> 0 0 NMOS_VTL L=50e-9 W='1*90e-9'
mn2414 col<110> sel<12> 0 0 NMOS_VTL L=50e-9 W='1*90e-9'
mn2418 col<114> sel<12> 0 0 NMOS_VTL L=50e-9 W='1*90e-9'
mn2427 col<123> sel<12> 0 0 NMOS_VTL L=50e-9 W='1*90e-9'
mn2428 col<124> sel<12> 0 0 NMOS_VTL L=50e-9 W='1*90e-9'
mn2429 col<125> sel<12> 0 0 NMOS_VTL L=50e-9 W='1*90e-9'
mn2431 col<127> sel<12> 0 0 NMOS_VTL L=50e-9 W='1*90e-9'
mn2434 col<130> sel<12> 0 0 NMOS_VTL L=50e-9 W='1*90e-9'
mn2436 col<132> sel<12> 0 0 NMOS_VTL L=50e-9 W='1*90e-9'
mn2442 col<138> sel<12> 0 0 NMOS_VTL L=50e-9 W='1*90e-9'
mn2443 col<139> sel<12> 0 0 NMOS_VTL L=50e-9 W='1*90e-9'
mn2444 col<140> sel<12> 0 0 NMOS_VTL L=50e-9 W='1*90e-9'
mn2448 col<144> sel<12> 0 0 NMOS_VTL L=50e-9 W='1*90e-9'
mn2449 col<145> sel<12> 0 0 NMOS_VTL L=50e-9 W='1*90e-9'
mn2450 col<146> sel<12> 0 0 NMOS_VTL L=50e-9 W='1*90e-9'
mn2460 col<156> sel<12> 0 0 NMOS_VTL L=50e-9 W='1*90e-9'
mn2472 col<168> sel<12> 0 0 NMOS_VTL L=50e-9 W='1*90e-9'
mn2473 col<169> sel<12> 0 0 NMOS_VTL L=50e-9 W='1*90e-9'
mn2474 col<170> sel<12> 0 0 NMOS_VTL L=50e-9 W='1*90e-9'
mn2475 col<171> sel<12> 0 0 NMOS_VTL L=50e-9 W='1*90e-9'
mn2476 col<172> sel<12> 0 0 NMOS_VTL L=50e-9 W='1*90e-9'
mn2477 col<173> sel<12> 0 0 NMOS_VTL L=50e-9 W='1*90e-9'
mn2478 col<174> sel<12> 0 0 NMOS_VTL L=50e-9 W='1*90e-9'
mn2479 col<175> sel<12> 0 0 NMOS_VTL L=50e-9 W='1*90e-9'
mn2480 col<176> sel<12> 0 0 NMOS_VTL L=50e-9 W='1*90e-9'
mn2481 col<177> sel<12> 0 0 NMOS_VTL L=50e-9 W='1*90e-9'
mn2482 col<178> sel<12> 0 0 NMOS_VTL L=50e-9 W='1*90e-9'
mn2483 col<179> sel<12> 0 0 NMOS_VTL L=50e-9 W='1*90e-9'
mn2484 col<180> sel<12> 0 0 NMOS_VTL L=50e-9 W='1*90e-9'
mn2485 col<181> sel<12> 0 0 NMOS_VTL L=50e-9 W='1*90e-9'
mn2486 col<182> sel<12> 0 0 NMOS_VTL L=50e-9 W='1*90e-9'
mn2487 col<183> sel<12> 0 0 NMOS_VTL L=50e-9 W='1*90e-9'
mn2488 col<184> sel<12> 0 0 NMOS_VTL L=50e-9 W='1*90e-9'
mn2489 col<185> sel<12> 0 0 NMOS_VTL L=50e-9 W='1*90e-9'
mn2490 col<186> sel<12> 0 0 NMOS_VTL L=50e-9 W='1*90e-9'
mn2491 col<187> sel<12> 0 0 NMOS_VTL L=50e-9 W='1*90e-9'
mn2492 col<188> sel<12> 0 0 NMOS_VTL L=50e-9 W='1*90e-9'
mn2496 col<0> sel<13> 0 0 NMOS_VTL L=50e-9 W='1*90e-9'
mn2497 col<1> sel<13> 0 0 NMOS_VTL L=50e-9 W='1*90e-9'
mn2498 col<2> sel<13> 0 0 NMOS_VTL L=50e-9 W='1*90e-9'
mn2502 col<6> sel<13> 0 0 NMOS_VTL L=50e-9 W='1*90e-9'
mn2503 col<7> sel<13> 0 0 NMOS_VTL L=50e-9 W='1*90e-9'
mn2504 col<8> sel<13> 0 0 NMOS_VTL L=50e-9 W='1*90e-9'
mn2508 col<12> sel<13> 0 0 NMOS_VTL L=50e-9 W='1*90e-9'
mn2509 col<13> sel<13> 0 0 NMOS_VTL L=50e-9 W='1*90e-9'
mn2510 col<14> sel<13> 0 0 NMOS_VTL L=50e-9 W='1*90e-9'
mn2514 col<18> sel<13> 0 0 NMOS_VTL L=50e-9 W='1*90e-9'
mn2515 col<19> sel<13> 0 0 NMOS_VTL L=50e-9 W='1*90e-9'
mn2516 col<20> sel<13> 0 0 NMOS_VTL L=50e-9 W='1*90e-9'
mn2517 col<21> sel<13> 0 0 NMOS_VTL L=50e-9 W='1*90e-9'
mn2518 col<22> sel<13> 0 0 NMOS_VTL L=50e-9 W='1*90e-9'
mn2519 col<23> sel<13> 0 0 NMOS_VTL L=50e-9 W='1*90e-9'
mn2520 col<24> sel<13> 0 0 NMOS_VTL L=50e-9 W='1*90e-9'
mn2521 col<25> sel<13> 0 0 NMOS_VTL L=50e-9 W='1*90e-9'
mn2522 col<26> sel<13> 0 0 NMOS_VTL L=50e-9 W='1*90e-9'
mn2523 col<27> sel<13> 0 0 NMOS_VTL L=50e-9 W='1*90e-9'
mn2524 col<28> sel<13> 0 0 NMOS_VTL L=50e-9 W='1*90e-9'
mn2525 col<29> sel<13> 0 0 NMOS_VTL L=50e-9 W='1*90e-9'
mn2526 col<30> sel<13> 0 0 NMOS_VTL L=50e-9 W='1*90e-9'
mn2527 col<31> sel<13> 0 0 NMOS_VTL L=50e-9 W='1*90e-9'
mn2528 col<32> sel<13> 0 0 NMOS_VTL L=50e-9 W='1*90e-9'
mn2529 col<33> sel<13> 0 0 NMOS_VTL L=50e-9 W='1*90e-9'
mn2530 col<34> sel<13> 0 0 NMOS_VTL L=50e-9 W='1*90e-9'
mn2531 col<35> sel<13> 0 0 NMOS_VTL L=50e-9 W='1*90e-9'
mn2535 col<39> sel<13> 0 0 NMOS_VTL L=50e-9 W='1*90e-9'
mn2544 col<48> sel<13> 0 0 NMOS_VTL L=50e-9 W='1*90e-9'
mn2545 col<49> sel<13> 0 0 NMOS_VTL L=50e-9 W='1*90e-9'
mn2546 col<50> sel<13> 0 0 NMOS_VTL L=50e-9 W='1*90e-9'
mn2550 col<54> sel<13> 0 0 NMOS_VTL L=50e-9 W='1*90e-9'
mn2551 col<55> sel<13> 0 0 NMOS_VTL L=50e-9 W='1*90e-9'
mn2552 col<56> sel<13> 0 0 NMOS_VTL L=50e-9 W='1*90e-9'
mn2553 col<57> sel<13> 0 0 NMOS_VTL L=50e-9 W='1*90e-9'
mn2556 col<60> sel<13> 0 0 NMOS_VTL L=50e-9 W='1*90e-9'
mn2565 col<69> sel<13> 0 0 NMOS_VTL L=50e-9 W='1*90e-9'
mn2566 col<70> sel<13> 0 0 NMOS_VTL L=50e-9 W='1*90e-9'
mn2567 col<71> sel<13> 0 0 NMOS_VTL L=50e-9 W='1*90e-9'
mn2580 col<84> sel<13> 0 0 NMOS_VTL L=50e-9 W='1*90e-9'
mn2581 col<85> sel<13> 0 0 NMOS_VTL L=50e-9 W='1*90e-9'
mn2582 col<86> sel<13> 0 0 NMOS_VTL L=50e-9 W='1*90e-9'
mn2584 col<88> sel<13> 0 0 NMOS_VTL L=50e-9 W='1*90e-9'
mn2585 col<89> sel<13> 0 0 NMOS_VTL L=50e-9 W='1*90e-9'
mn2586 col<90> sel<13> 0 0 NMOS_VTL L=50e-9 W='1*90e-9'
mn2587 col<91> sel<13> 0 0 NMOS_VTL L=50e-9 W='1*90e-9'
mn2588 col<92> sel<13> 0 0 NMOS_VTL L=50e-9 W='1*90e-9'
mn2592 col<96> sel<13> 0 0 NMOS_VTL L=50e-9 W='1*90e-9'
mn2593 col<97> sel<13> 0 0 NMOS_VTL L=50e-9 W='1*90e-9'
mn2594 col<98> sel<13> 0 0 NMOS_VTL L=50e-9 W='1*90e-9'
mn2598 col<102> sel<13> 0 0 NMOS_VTL L=50e-9 W='1*90e-9'
mn2599 col<103> sel<13> 0 0 NMOS_VTL L=50e-9 W='1*90e-9'
mn2600 col<104> sel<13> 0 0 NMOS_VTL L=50e-9 W='1*90e-9'
mn2602 col<106> sel<13> 0 0 NMOS_VTL L=50e-9 W='1*90e-9'
mn2603 col<107> sel<13> 0 0 NMOS_VTL L=50e-9 W='1*90e-9'
mn2604 col<108> sel<13> 0 0 NMOS_VTL L=50e-9 W='1*90e-9'
mn2605 col<109> sel<13> 0 0 NMOS_VTL L=50e-9 W='1*90e-9'
mn2606 col<110> sel<13> 0 0 NMOS_VTL L=50e-9 W='1*90e-9'
mn2613 col<117> sel<13> 0 0 NMOS_VTL L=50e-9 W='1*90e-9'
mn2614 col<118> sel<13> 0 0 NMOS_VTL L=50e-9 W='1*90e-9'
mn2615 col<119> sel<13> 0 0 NMOS_VTL L=50e-9 W='1*90e-9'
mn2619 col<123> sel<13> 0 0 NMOS_VTL L=50e-9 W='1*90e-9'
mn2625 col<129> sel<13> 0 0 NMOS_VTL L=50e-9 W='1*90e-9'
mn2626 col<130> sel<13> 0 0 NMOS_VTL L=50e-9 W='1*90e-9'
mn2627 col<131> sel<13> 0 0 NMOS_VTL L=50e-9 W='1*90e-9'
mn2628 col<132> sel<13> 0 0 NMOS_VTL L=50e-9 W='1*90e-9'
mn2629 col<133> sel<13> 0 0 NMOS_VTL L=50e-9 W='1*90e-9'
mn2630 col<134> sel<13> 0 0 NMOS_VTL L=50e-9 W='1*90e-9'
mn2631 col<135> sel<13> 0 0 NMOS_VTL L=50e-9 W='1*90e-9'
mn2637 col<141> sel<13> 0 0 NMOS_VTL L=50e-9 W='1*90e-9'
mn2638 col<142> sel<13> 0 0 NMOS_VTL L=50e-9 W='1*90e-9'
mn2639 col<143> sel<13> 0 0 NMOS_VTL L=50e-9 W='1*90e-9'
mn2646 col<150> sel<13> 0 0 NMOS_VTL L=50e-9 W='1*90e-9'
mn2649 col<153> sel<13> 0 0 NMOS_VTL L=50e-9 W='1*90e-9'
mn2652 col<156> sel<13> 0 0 NMOS_VTL L=50e-9 W='1*90e-9'
mn2658 col<162> sel<13> 0 0 NMOS_VTL L=50e-9 W='1*90e-9'
mn2659 col<163> sel<13> 0 0 NMOS_VTL L=50e-9 W='1*90e-9'
mn2660 col<164> sel<13> 0 0 NMOS_VTL L=50e-9 W='1*90e-9'
mn2667 col<171> sel<13> 0 0 NMOS_VTL L=50e-9 W='1*90e-9'
mn2668 col<172> sel<13> 0 0 NMOS_VTL L=50e-9 W='1*90e-9'
mn2669 col<173> sel<13> 0 0 NMOS_VTL L=50e-9 W='1*90e-9'
mn2680 col<184> sel<13> 0 0 NMOS_VTL L=50e-9 W='1*90e-9'
mn2681 col<185> sel<13> 0 0 NMOS_VTL L=50e-9 W='1*90e-9'
mn2682 col<186> sel<13> 0 0 NMOS_VTL L=50e-9 W='1*90e-9'
mn2683 col<187> sel<13> 0 0 NMOS_VTL L=50e-9 W='1*90e-9'
mn2684 col<188> sel<13> 0 0 NMOS_VTL L=50e-9 W='1*90e-9'
mn2688 col<0> sel<14> 0 0 NMOS_VTL L=50e-9 W='1*90e-9'
mn2689 col<1> sel<14> 0 0 NMOS_VTL L=50e-9 W='1*90e-9'
mn2690 col<2> sel<14> 0 0 NMOS_VTL L=50e-9 W='1*90e-9'
mn2697 col<9> sel<14> 0 0 NMOS_VTL L=50e-9 W='1*90e-9'
mn2698 col<10> sel<14> 0 0 NMOS_VTL L=50e-9 W='1*90e-9'
mn2699 col<11> sel<14> 0 0 NMOS_VTL L=50e-9 W='1*90e-9'
mn2700 col<12> sel<14> 0 0 NMOS_VTL L=50e-9 W='1*90e-9'
mn2701 col<13> sel<14> 0 0 NMOS_VTL L=50e-9 W='1*90e-9'
mn2702 col<14> sel<14> 0 0 NMOS_VTL L=50e-9 W='1*90e-9'
mn2715 col<27> sel<14> 0 0 NMOS_VTL L=50e-9 W='1*90e-9'
mn2716 col<28> sel<14> 0 0 NMOS_VTL L=50e-9 W='1*90e-9'
mn2717 col<29> sel<14> 0 0 NMOS_VTL L=50e-9 W='1*90e-9'
mn2721 col<33> sel<14> 0 0 NMOS_VTL L=50e-9 W='1*90e-9'
mn2722 col<34> sel<14> 0 0 NMOS_VTL L=50e-9 W='1*90e-9'
mn2723 col<35> sel<14> 0 0 NMOS_VTL L=50e-9 W='1*90e-9'
mn2724 col<36> sel<14> 0 0 NMOS_VTL L=50e-9 W='1*90e-9'
mn2725 col<37> sel<14> 0 0 NMOS_VTL L=50e-9 W='1*90e-9'
mn2726 col<38> sel<14> 0 0 NMOS_VTL L=50e-9 W='1*90e-9'
mn2730 col<42> sel<14> 0 0 NMOS_VTL L=50e-9 W='1*90e-9'
mn2731 col<43> sel<14> 0 0 NMOS_VTL L=50e-9 W='1*90e-9'
mn2732 col<44> sel<14> 0 0 NMOS_VTL L=50e-9 W='1*90e-9'
mn2733 col<45> sel<14> 0 0 NMOS_VTL L=50e-9 W='1*90e-9'
mn2734 col<46> sel<14> 0 0 NMOS_VTL L=50e-9 W='1*90e-9'
mn2735 col<47> sel<14> 0 0 NMOS_VTL L=50e-9 W='1*90e-9'
mn2736 col<48> sel<14> 0 0 NMOS_VTL L=50e-9 W='1*90e-9'
mn2737 col<49> sel<14> 0 0 NMOS_VTL L=50e-9 W='1*90e-9'
mn2738 col<50> sel<14> 0 0 NMOS_VTL L=50e-9 W='1*90e-9'
mn2745 col<57> sel<14> 0 0 NMOS_VTL L=50e-9 W='1*90e-9'
mn2746 col<58> sel<14> 0 0 NMOS_VTL L=50e-9 W='1*90e-9'
mn2747 col<59> sel<14> 0 0 NMOS_VTL L=50e-9 W='1*90e-9'
mn2751 col<63> sel<14> 0 0 NMOS_VTL L=50e-9 W='1*90e-9'
mn2752 col<64> sel<14> 0 0 NMOS_VTL L=50e-9 W='1*90e-9'
mn2753 col<65> sel<14> 0 0 NMOS_VTL L=50e-9 W='1*90e-9'
mn2757 col<69> sel<14> 0 0 NMOS_VTL L=50e-9 W='1*90e-9'
mn2758 col<70> sel<14> 0 0 NMOS_VTL L=50e-9 W='1*90e-9'
mn2759 col<71> sel<14> 0 0 NMOS_VTL L=50e-9 W='1*90e-9'
mn2760 col<72> sel<14> 0 0 NMOS_VTL L=50e-9 W='1*90e-9'
mn2761 col<73> sel<14> 0 0 NMOS_VTL L=50e-9 W='1*90e-9'
mn2762 col<74> sel<14> 0 0 NMOS_VTL L=50e-9 W='1*90e-9'
mn2769 col<81> sel<14> 0 0 NMOS_VTL L=50e-9 W='1*90e-9'
mn2770 col<82> sel<14> 0 0 NMOS_VTL L=50e-9 W='1*90e-9'
mn2771 col<83> sel<14> 0 0 NMOS_VTL L=50e-9 W='1*90e-9'
mn2772 col<84> sel<14> 0 0 NMOS_VTL L=50e-9 W='1*90e-9'
mn2773 col<85> sel<14> 0 0 NMOS_VTL L=50e-9 W='1*90e-9'
mn2774 col<86> sel<14> 0 0 NMOS_VTL L=50e-9 W='1*90e-9'
mn2778 col<90> sel<14> 0 0 NMOS_VTL L=50e-9 W='1*90e-9'
mn2779 col<91> sel<14> 0 0 NMOS_VTL L=50e-9 W='1*90e-9'
mn2780 col<92> sel<14> 0 0 NMOS_VTL L=50e-9 W='1*90e-9'
mn2790 col<102> sel<14> 0 0 NMOS_VTL L=50e-9 W='1*90e-9'
mn2791 col<103> sel<14> 0 0 NMOS_VTL L=50e-9 W='1*90e-9'
mn2792 col<104> sel<14> 0 0 NMOS_VTL L=50e-9 W='1*90e-9'
mn2793 col<105> sel<14> 0 0 NMOS_VTL L=50e-9 W='1*90e-9'
mn2794 col<106> sel<14> 0 0 NMOS_VTL L=50e-9 W='1*90e-9'
mn2795 col<107> sel<14> 0 0 NMOS_VTL L=50e-9 W='1*90e-9'
mn2799 col<111> sel<14> 0 0 NMOS_VTL L=50e-9 W='1*90e-9'
mn2800 col<112> sel<14> 0 0 NMOS_VTL L=50e-9 W='1*90e-9'
mn2801 col<113> sel<14> 0 0 NMOS_VTL L=50e-9 W='1*90e-9'
mn2814 col<126> sel<14> 0 0 NMOS_VTL L=50e-9 W='1*90e-9'
mn2815 col<127> sel<14> 0 0 NMOS_VTL L=50e-9 W='1*90e-9'
mn2816 col<128> sel<14> 0 0 NMOS_VTL L=50e-9 W='1*90e-9'
mn2820 col<132> sel<14> 0 0 NMOS_VTL L=50e-9 W='1*90e-9'
mn2821 col<133> sel<14> 0 0 NMOS_VTL L=50e-9 W='1*90e-9'
mn2822 col<134> sel<14> 0 0 NMOS_VTL L=50e-9 W='1*90e-9'
mn2823 col<135> sel<14> 0 0 NMOS_VTL L=50e-9 W='1*90e-9'
mn2824 col<136> sel<14> 0 0 NMOS_VTL L=50e-9 W='1*90e-9'
mn2825 col<137> sel<14> 0 0 NMOS_VTL L=50e-9 W='1*90e-9'
mn2826 col<138> sel<14> 0 0 NMOS_VTL L=50e-9 W='1*90e-9'
mn2827 col<139> sel<14> 0 0 NMOS_VTL L=50e-9 W='1*90e-9'
mn2828 col<140> sel<14> 0 0 NMOS_VTL L=50e-9 W='1*90e-9'
mn2835 col<147> sel<14> 0 0 NMOS_VTL L=50e-9 W='1*90e-9'
mn2836 col<148> sel<14> 0 0 NMOS_VTL L=50e-9 W='1*90e-9'
mn2837 col<149> sel<14> 0 0 NMOS_VTL L=50e-9 W='1*90e-9'
mn2841 col<153> sel<14> 0 0 NMOS_VTL L=50e-9 W='1*90e-9'
mn2842 col<154> sel<14> 0 0 NMOS_VTL L=50e-9 W='1*90e-9'
mn2843 col<155> sel<14> 0 0 NMOS_VTL L=50e-9 W='1*90e-9'
mn2844 col<156> sel<14> 0 0 NMOS_VTL L=50e-9 W='1*90e-9'
mn2845 col<157> sel<14> 0 0 NMOS_VTL L=50e-9 W='1*90e-9'
mn2846 col<158> sel<14> 0 0 NMOS_VTL L=50e-9 W='1*90e-9'
mn2850 col<162> sel<14> 0 0 NMOS_VTL L=50e-9 W='1*90e-9'
mn2851 col<163> sel<14> 0 0 NMOS_VTL L=50e-9 W='1*90e-9'
mn2852 col<164> sel<14> 0 0 NMOS_VTL L=50e-9 W='1*90e-9'
mn2853 col<165> sel<14> 0 0 NMOS_VTL L=50e-9 W='1*90e-9'
mn2854 col<166> sel<14> 0 0 NMOS_VTL L=50e-9 W='1*90e-9'
mn2855 col<167> sel<14> 0 0 NMOS_VTL L=50e-9 W='1*90e-9'
mn2859 col<171> sel<14> 0 0 NMOS_VTL L=50e-9 W='1*90e-9'
mn2860 col<172> sel<14> 0 0 NMOS_VTL L=50e-9 W='1*90e-9'
mn2861 col<173> sel<14> 0 0 NMOS_VTL L=50e-9 W='1*90e-9'
mn2874 col<186> sel<14> 0 0 NMOS_VTL L=50e-9 W='1*90e-9'
mn2875 col<187> sel<14> 0 0 NMOS_VTL L=50e-9 W='1*90e-9'
mn2876 col<188> sel<14> 0 0 NMOS_VTL L=50e-9 W='1*90e-9'
mn2877 col<189> sel<14> 0 0 NMOS_VTL L=50e-9 W='1*90e-9'
mn2878 col<190> sel<14> 0 0 NMOS_VTL L=50e-9 W='1*90e-9'
mn2879 col<191> sel<14> 0 0 NMOS_VTL L=50e-9 W='1*90e-9'
mn2880 col<0> sel<15> 0 0 NMOS_VTL L=50e-9 W='1*90e-9'
mn2881 col<1> sel<15> 0 0 NMOS_VTL L=50e-9 W='1*90e-9'
mn2882 col<2> sel<15> 0 0 NMOS_VTL L=50e-9 W='1*90e-9'
mn2886 col<6> sel<15> 0 0 NMOS_VTL L=50e-9 W='1*90e-9'
mn2887 col<7> sel<15> 0 0 NMOS_VTL L=50e-9 W='1*90e-9'
mn2888 col<8> sel<15> 0 0 NMOS_VTL L=50e-9 W='1*90e-9'
mn2895 col<15> sel<15> 0 0 NMOS_VTL L=50e-9 W='1*90e-9'
mn2896 col<16> sel<15> 0 0 NMOS_VTL L=50e-9 W='1*90e-9'
mn2897 col<17> sel<15> 0 0 NMOS_VTL L=50e-9 W='1*90e-9'
mn2907 col<27> sel<15> 0 0 NMOS_VTL L=50e-9 W='1*90e-9'
mn2908 col<28> sel<15> 0 0 NMOS_VTL L=50e-9 W='1*90e-9'
mn2909 col<29> sel<15> 0 0 NMOS_VTL L=50e-9 W='1*90e-9'
mn2910 col<30> sel<15> 0 0 NMOS_VTL L=50e-9 W='1*90e-9'
mn2911 col<31> sel<15> 0 0 NMOS_VTL L=50e-9 W='1*90e-9'
mn2912 col<32> sel<15> 0 0 NMOS_VTL L=50e-9 W='1*90e-9'
mn2916 col<36> sel<15> 0 0 NMOS_VTL L=50e-9 W='1*90e-9'
mn2917 col<37> sel<15> 0 0 NMOS_VTL L=50e-9 W='1*90e-9'
mn2918 col<38> sel<15> 0 0 NMOS_VTL L=50e-9 W='1*90e-9'
mn2934 col<54> sel<15> 0 0 NMOS_VTL L=50e-9 W='1*90e-9'
mn2935 col<55> sel<15> 0 0 NMOS_VTL L=50e-9 W='1*90e-9'
mn2936 col<56> sel<15> 0 0 NMOS_VTL L=50e-9 W='1*90e-9'
mn2937 col<57> sel<15> 0 0 NMOS_VTL L=50e-9 W='1*90e-9'
mn2938 col<58> sel<15> 0 0 NMOS_VTL L=50e-9 W='1*90e-9'
mn2939 col<59> sel<15> 0 0 NMOS_VTL L=50e-9 W='1*90e-9'
mn2940 col<60> sel<15> 0 0 NMOS_VTL L=50e-9 W='1*90e-9'
mn2941 col<61> sel<15> 0 0 NMOS_VTL L=50e-9 W='1*90e-9'
mn2942 col<62> sel<15> 0 0 NMOS_VTL L=50e-9 W='1*90e-9'
mn2943 col<63> sel<15> 0 0 NMOS_VTL L=50e-9 W='1*90e-9'
mn2944 col<64> sel<15> 0 0 NMOS_VTL L=50e-9 W='1*90e-9'
mn2945 col<65> sel<15> 0 0 NMOS_VTL L=50e-9 W='1*90e-9'
mn2949 col<69> sel<15> 0 0 NMOS_VTL L=50e-9 W='1*90e-9'
mn2950 col<70> sel<15> 0 0 NMOS_VTL L=50e-9 W='1*90e-9'
mn2951 col<71> sel<15> 0 0 NMOS_VTL L=50e-9 W='1*90e-9'
mn2952 col<72> sel<15> 0 0 NMOS_VTL L=50e-9 W='1*90e-9'
mn2953 col<73> sel<15> 0 0 NMOS_VTL L=50e-9 W='1*90e-9'
mn2954 col<74> sel<15> 0 0 NMOS_VTL L=50e-9 W='1*90e-9'
mn2955 col<75> sel<15> 0 0 NMOS_VTL L=50e-9 W='1*90e-9'
mn2956 col<76> sel<15> 0 0 NMOS_VTL L=50e-9 W='1*90e-9'
mn2957 col<77> sel<15> 0 0 NMOS_VTL L=50e-9 W='1*90e-9'
mn2961 col<81> sel<15> 0 0 NMOS_VTL L=50e-9 W='1*90e-9'
mn2962 col<82> sel<15> 0 0 NMOS_VTL L=50e-9 W='1*90e-9'
mn2963 col<83> sel<15> 0 0 NMOS_VTL L=50e-9 W='1*90e-9'
mn2964 col<84> sel<15> 0 0 NMOS_VTL L=50e-9 W='1*90e-9'
mn2965 col<85> sel<15> 0 0 NMOS_VTL L=50e-9 W='1*90e-9'
mn2966 col<86> sel<15> 0 0 NMOS_VTL L=50e-9 W='1*90e-9'
mn2967 col<87> sel<15> 0 0 NMOS_VTL L=50e-9 W='1*90e-9'
mn2968 col<88> sel<15> 0 0 NMOS_VTL L=50e-9 W='1*90e-9'
mn2969 col<89> sel<15> 0 0 NMOS_VTL L=50e-9 W='1*90e-9'
mn2970 col<90> sel<15> 0 0 NMOS_VTL L=50e-9 W='1*90e-9'
mn2971 col<91> sel<15> 0 0 NMOS_VTL L=50e-9 W='1*90e-9'
mn2972 col<92> sel<15> 0 0 NMOS_VTL L=50e-9 W='1*90e-9'
mn2976 col<96> sel<15> 0 0 NMOS_VTL L=50e-9 W='1*90e-9'
mn2977 col<97> sel<15> 0 0 NMOS_VTL L=50e-9 W='1*90e-9'
mn2978 col<98> sel<15> 0 0 NMOS_VTL L=50e-9 W='1*90e-9'
mn2979 col<99> sel<15> 0 0 NMOS_VTL L=50e-9 W='1*90e-9'
mn2980 col<100> sel<15> 0 0 NMOS_VTL L=50e-9 W='1*90e-9'
mn2981 col<101> sel<15> 0 0 NMOS_VTL L=50e-9 W='1*90e-9'
mn2985 col<105> sel<15> 0 0 NMOS_VTL L=50e-9 W='1*90e-9'
mn2986 col<106> sel<15> 0 0 NMOS_VTL L=50e-9 W='1*90e-9'
mn2987 col<107> sel<15> 0 0 NMOS_VTL L=50e-9 W='1*90e-9'
mn2988 col<108> sel<15> 0 0 NMOS_VTL L=50e-9 W='1*90e-9'
mn2989 col<109> sel<15> 0 0 NMOS_VTL L=50e-9 W='1*90e-9'
mn2990 col<110> sel<15> 0 0 NMOS_VTL L=50e-9 W='1*90e-9'
mn2997 col<117> sel<15> 0 0 NMOS_VTL L=50e-9 W='1*90e-9'
mn2998 col<118> sel<15> 0 0 NMOS_VTL L=50e-9 W='1*90e-9'
mn2999 col<119> sel<15> 0 0 NMOS_VTL L=50e-9 W='1*90e-9'
mn3003 col<123> sel<15> 0 0 NMOS_VTL L=50e-9 W='1*90e-9'
mn3004 col<124> sel<15> 0 0 NMOS_VTL L=50e-9 W='1*90e-9'
mn3005 col<125> sel<15> 0 0 NMOS_VTL L=50e-9 W='1*90e-9'
mn3006 col<126> sel<15> 0 0 NMOS_VTL L=50e-9 W='1*90e-9'
mn3007 col<127> sel<15> 0 0 NMOS_VTL L=50e-9 W='1*90e-9'
mn3008 col<128> sel<15> 0 0 NMOS_VTL L=50e-9 W='1*90e-9'
mn3009 col<129> sel<15> 0 0 NMOS_VTL L=50e-9 W='1*90e-9'
mn3010 col<130> sel<15> 0 0 NMOS_VTL L=50e-9 W='1*90e-9'
mn3011 col<131> sel<15> 0 0 NMOS_VTL L=50e-9 W='1*90e-9'
mn3012 col<132> sel<15> 0 0 NMOS_VTL L=50e-9 W='1*90e-9'
mn3013 col<133> sel<15> 0 0 NMOS_VTL L=50e-9 W='1*90e-9'
mn3014 col<134> sel<15> 0 0 NMOS_VTL L=50e-9 W='1*90e-9'
mn3015 col<135> sel<15> 0 0 NMOS_VTL L=50e-9 W='1*90e-9'
mn3016 col<136> sel<15> 0 0 NMOS_VTL L=50e-9 W='1*90e-9'
mn3017 col<137> sel<15> 0 0 NMOS_VTL L=50e-9 W='1*90e-9'
mn3030 col<150> sel<15> 0 0 NMOS_VTL L=50e-9 W='1*90e-9'
mn3031 col<151> sel<15> 0 0 NMOS_VTL L=50e-9 W='1*90e-9'
mn3032 col<152> sel<15> 0 0 NMOS_VTL L=50e-9 W='1*90e-9'
mn3048 col<168> sel<15> 0 0 NMOS_VTL L=50e-9 W='1*90e-9'
mn3049 col<169> sel<15> 0 0 NMOS_VTL L=50e-9 W='1*90e-9'
mn3050 col<170> sel<15> 0 0 NMOS_VTL L=50e-9 W='1*90e-9'
mn3054 col<174> sel<15> 0 0 NMOS_VTL L=50e-9 W='1*90e-9'
mn3055 col<175> sel<15> 0 0 NMOS_VTL L=50e-9 W='1*90e-9'
mn3056 col<176> sel<15> 0 0 NMOS_VTL L=50e-9 W='1*90e-9'
mn3057 col<177> sel<15> 0 0 NMOS_VTL L=50e-9 W='1*90e-9'
mn3058 col<178> sel<15> 0 0 NMOS_VTL L=50e-9 W='1*90e-9'
mn3059 col<179> sel<15> 0 0 NMOS_VTL L=50e-9 W='1*90e-9'
mn3060 col<180> sel<15> 0 0 NMOS_VTL L=50e-9 W='1*90e-9'
mn3061 col<181> sel<15> 0 0 NMOS_VTL L=50e-9 W='1*90e-9'
mn3062 col<182> sel<15> 0 0 NMOS_VTL L=50e-9 W='1*90e-9'
mn3072 col<0> sel<16> 0 0 NMOS_VTL L=50e-9 W='1*90e-9'
mn3073 col<1> sel<16> 0 0 NMOS_VTL L=50e-9 W='1*90e-9'
mn3074 col<2> sel<16> 0 0 NMOS_VTL L=50e-9 W='1*90e-9'
mn3078 col<6> sel<16> 0 0 NMOS_VTL L=50e-9 W='1*90e-9'
mn3079 col<7> sel<16> 0 0 NMOS_VTL L=50e-9 W='1*90e-9'
mn3080 col<8> sel<16> 0 0 NMOS_VTL L=50e-9 W='1*90e-9'
mn3081 col<9> sel<16> 0 0 NMOS_VTL L=50e-9 W='1*90e-9'
mn3082 col<10> sel<16> 0 0 NMOS_VTL L=50e-9 W='1*90e-9'
mn3083 col<11> sel<16> 0 0 NMOS_VTL L=50e-9 W='1*90e-9'
mn3087 col<15> sel<16> 0 0 NMOS_VTL L=50e-9 W='1*90e-9'
mn3088 col<16> sel<16> 0 0 NMOS_VTL L=50e-9 W='1*90e-9'
mn3089 col<17> sel<16> 0 0 NMOS_VTL L=50e-9 W='1*90e-9'
mn3090 col<18> sel<16> 0 0 NMOS_VTL L=50e-9 W='1*90e-9'
mn3091 col<19> sel<16> 0 0 NMOS_VTL L=50e-9 W='1*90e-9'
mn3092 col<20> sel<16> 0 0 NMOS_VTL L=50e-9 W='1*90e-9'
mn3093 col<21> sel<16> 0 0 NMOS_VTL L=50e-9 W='1*90e-9'
mn3094 col<22> sel<16> 0 0 NMOS_VTL L=50e-9 W='1*90e-9'
mn3095 col<23> sel<16> 0 0 NMOS_VTL L=50e-9 W='1*90e-9'
mn3096 col<24> sel<16> 0 0 NMOS_VTL L=50e-9 W='1*90e-9'
mn3097 col<25> sel<16> 0 0 NMOS_VTL L=50e-9 W='1*90e-9'
mn3098 col<26> sel<16> 0 0 NMOS_VTL L=50e-9 W='1*90e-9'
mn3099 col<27> sel<16> 0 0 NMOS_VTL L=50e-9 W='1*90e-9'
mn3100 col<28> sel<16> 0 0 NMOS_VTL L=50e-9 W='1*90e-9'
mn3101 col<29> sel<16> 0 0 NMOS_VTL L=50e-9 W='1*90e-9'
mn3105 col<33> sel<16> 0 0 NMOS_VTL L=50e-9 W='1*90e-9'
mn3106 col<34> sel<16> 0 0 NMOS_VTL L=50e-9 W='1*90e-9'
mn3107 col<35> sel<16> 0 0 NMOS_VTL L=50e-9 W='1*90e-9'
mn3108 col<36> sel<16> 0 0 NMOS_VTL L=50e-9 W='1*90e-9'
mn3109 col<37> sel<16> 0 0 NMOS_VTL L=50e-9 W='1*90e-9'
mn3110 col<38> sel<16> 0 0 NMOS_VTL L=50e-9 W='1*90e-9'
mn3111 col<39> sel<16> 0 0 NMOS_VTL L=50e-9 W='1*90e-9'
mn3112 col<40> sel<16> 0 0 NMOS_VTL L=50e-9 W='1*90e-9'
mn3113 col<41> sel<16> 0 0 NMOS_VTL L=50e-9 W='1*90e-9'
mn3115 col<43> sel<16> 0 0 NMOS_VTL L=50e-9 W='1*90e-9'
mn3116 col<44> sel<16> 0 0 NMOS_VTL L=50e-9 W='1*90e-9'
mn3118 col<46> sel<16> 0 0 NMOS_VTL L=50e-9 W='1*90e-9'
mn3119 col<47> sel<16> 0 0 NMOS_VTL L=50e-9 W='1*90e-9'
mn3120 col<48> sel<16> 0 0 NMOS_VTL L=50e-9 W='1*90e-9'
mn3121 col<49> sel<16> 0 0 NMOS_VTL L=50e-9 W='1*90e-9'
mn3122 col<50> sel<16> 0 0 NMOS_VTL L=50e-9 W='1*90e-9'
mn3123 col<51> sel<16> 0 0 NMOS_VTL L=50e-9 W='1*90e-9'
mn3124 col<52> sel<16> 0 0 NMOS_VTL L=50e-9 W='1*90e-9'
mn3125 col<53> sel<16> 0 0 NMOS_VTL L=50e-9 W='1*90e-9'
mn3132 col<60> sel<16> 0 0 NMOS_VTL L=50e-9 W='1*90e-9'
mn3138 col<66> sel<16> 0 0 NMOS_VTL L=50e-9 W='1*90e-9'
mn3139 col<67> sel<16> 0 0 NMOS_VTL L=50e-9 W='1*90e-9'
mn3140 col<68> sel<16> 0 0 NMOS_VTL L=50e-9 W='1*90e-9'
mn3141 col<69> sel<16> 0 0 NMOS_VTL L=50e-9 W='1*90e-9'
mn3142 col<70> sel<16> 0 0 NMOS_VTL L=50e-9 W='1*90e-9'
mn3143 col<71> sel<16> 0 0 NMOS_VTL L=50e-9 W='1*90e-9'
mn3144 col<72> sel<16> 0 0 NMOS_VTL L=50e-9 W='1*90e-9'
mn3145 col<73> sel<16> 0 0 NMOS_VTL L=50e-9 W='1*90e-9'
mn3146 col<74> sel<16> 0 0 NMOS_VTL L=50e-9 W='1*90e-9'
mn3147 col<75> sel<16> 0 0 NMOS_VTL L=50e-9 W='1*90e-9'
mn3148 col<76> sel<16> 0 0 NMOS_VTL L=50e-9 W='1*90e-9'
mn3149 col<77> sel<16> 0 0 NMOS_VTL L=50e-9 W='1*90e-9'
mn3151 col<79> sel<16> 0 0 NMOS_VTL L=50e-9 W='1*90e-9'
mn3152 col<80> sel<16> 0 0 NMOS_VTL L=50e-9 W='1*90e-9'
mn3154 col<82> sel<16> 0 0 NMOS_VTL L=50e-9 W='1*90e-9'
mn3155 col<83> sel<16> 0 0 NMOS_VTL L=50e-9 W='1*90e-9'
mn3156 col<84> sel<16> 0 0 NMOS_VTL L=50e-9 W='1*90e-9'
mn3157 col<85> sel<16> 0 0 NMOS_VTL L=50e-9 W='1*90e-9'
mn3158 col<86> sel<16> 0 0 NMOS_VTL L=50e-9 W='1*90e-9'
mn3160 col<88> sel<16> 0 0 NMOS_VTL L=50e-9 W='1*90e-9'
mn3162 col<90> sel<16> 0 0 NMOS_VTL L=50e-9 W='1*90e-9'
mn3163 col<91> sel<16> 0 0 NMOS_VTL L=50e-9 W='1*90e-9'
mn3164 col<92> sel<16> 0 0 NMOS_VTL L=50e-9 W='1*90e-9'
mn3165 col<93> sel<16> 0 0 NMOS_VTL L=50e-9 W='1*90e-9'
mn3166 col<94> sel<16> 0 0 NMOS_VTL L=50e-9 W='1*90e-9'
mn3167 col<95> sel<16> 0 0 NMOS_VTL L=50e-9 W='1*90e-9'
mn3168 col<96> sel<16> 0 0 NMOS_VTL L=50e-9 W='1*90e-9'
mn3169 col<97> sel<16> 0 0 NMOS_VTL L=50e-9 W='1*90e-9'
mn3170 col<98> sel<16> 0 0 NMOS_VTL L=50e-9 W='1*90e-9'
mn3178 col<106> sel<16> 0 0 NMOS_VTL L=50e-9 W='1*90e-9'
mn3179 col<107> sel<16> 0 0 NMOS_VTL L=50e-9 W='1*90e-9'
mn3183 col<111> sel<16> 0 0 NMOS_VTL L=50e-9 W='1*90e-9'
mn3186 col<114> sel<16> 0 0 NMOS_VTL L=50e-9 W='1*90e-9'
mn3187 col<115> sel<16> 0 0 NMOS_VTL L=50e-9 W='1*90e-9'
mn3188 col<116> sel<16> 0 0 NMOS_VTL L=50e-9 W='1*90e-9'
mn3195 col<123> sel<16> 0 0 NMOS_VTL L=50e-9 W='1*90e-9'
mn3196 col<124> sel<16> 0 0 NMOS_VTL L=50e-9 W='1*90e-9'
mn3197 col<125> sel<16> 0 0 NMOS_VTL L=50e-9 W='1*90e-9'
mn3198 col<126> sel<16> 0 0 NMOS_VTL L=50e-9 W='1*90e-9'
mn3199 col<127> sel<16> 0 0 NMOS_VTL L=50e-9 W='1*90e-9'
mn3200 col<128> sel<16> 0 0 NMOS_VTL L=50e-9 W='1*90e-9'
mn3204 col<132> sel<16> 0 0 NMOS_VTL L=50e-9 W='1*90e-9'
mn3207 col<135> sel<16> 0 0 NMOS_VTL L=50e-9 W='1*90e-9'
mn3208 col<136> sel<16> 0 0 NMOS_VTL L=50e-9 W='1*90e-9'
mn3209 col<137> sel<16> 0 0 NMOS_VTL L=50e-9 W='1*90e-9'
mn3213 col<141> sel<16> 0 0 NMOS_VTL L=50e-9 W='1*90e-9'
mn3214 col<142> sel<16> 0 0 NMOS_VTL L=50e-9 W='1*90e-9'
mn3215 col<143> sel<16> 0 0 NMOS_VTL L=50e-9 W='1*90e-9'
mn3222 col<150> sel<16> 0 0 NMOS_VTL L=50e-9 W='1*90e-9'
mn3223 col<151> sel<16> 0 0 NMOS_VTL L=50e-9 W='1*90e-9'
mn3224 col<152> sel<16> 0 0 NMOS_VTL L=50e-9 W='1*90e-9'
mn3231 col<159> sel<16> 0 0 NMOS_VTL L=50e-9 W='1*90e-9'
mn3232 col<160> sel<16> 0 0 NMOS_VTL L=50e-9 W='1*90e-9'
mn3233 col<161> sel<16> 0 0 NMOS_VTL L=50e-9 W='1*90e-9'
mn3240 col<168> sel<16> 0 0 NMOS_VTL L=50e-9 W='1*90e-9'
mn3241 col<169> sel<16> 0 0 NMOS_VTL L=50e-9 W='1*90e-9'
mn3242 col<170> sel<16> 0 0 NMOS_VTL L=50e-9 W='1*90e-9'
mn3243 col<171> sel<16> 0 0 NMOS_VTL L=50e-9 W='1*90e-9'
mn3244 col<172> sel<16> 0 0 NMOS_VTL L=50e-9 W='1*90e-9'
mn3245 col<173> sel<16> 0 0 NMOS_VTL L=50e-9 W='1*90e-9'
mn3246 col<174> sel<16> 0 0 NMOS_VTL L=50e-9 W='1*90e-9'
mn3247 col<175> sel<16> 0 0 NMOS_VTL L=50e-9 W='1*90e-9'
mn3248 col<176> sel<16> 0 0 NMOS_VTL L=50e-9 W='1*90e-9'
mn3255 col<183> sel<16> 0 0 NMOS_VTL L=50e-9 W='1*90e-9'
mn3256 col<184> sel<16> 0 0 NMOS_VTL L=50e-9 W='1*90e-9'
mn3257 col<185> sel<16> 0 0 NMOS_VTL L=50e-9 W='1*90e-9'
mn3258 col<186> sel<16> 0 0 NMOS_VTL L=50e-9 W='1*90e-9'
mn3259 col<187> sel<16> 0 0 NMOS_VTL L=50e-9 W='1*90e-9'
mn3260 col<188> sel<16> 0 0 NMOS_VTL L=50e-9 W='1*90e-9'
mn3261 col<189> sel<16> 0 0 NMOS_VTL L=50e-9 W='1*90e-9'
mn3262 col<190> sel<16> 0 0 NMOS_VTL L=50e-9 W='1*90e-9'
mn3263 col<191> sel<16> 0 0 NMOS_VTL L=50e-9 W='1*90e-9'
mn3264 col<0> sel<17> 0 0 NMOS_VTL L=50e-9 W='1*90e-9'
mn3265 col<1> sel<17> 0 0 NMOS_VTL L=50e-9 W='1*90e-9'
mn3266 col<2> sel<17> 0 0 NMOS_VTL L=50e-9 W='1*90e-9'
mn3270 col<6> sel<17> 0 0 NMOS_VTL L=50e-9 W='1*90e-9'
mn3271 col<7> sel<17> 0 0 NMOS_VTL L=50e-9 W='1*90e-9'
mn3272 col<8> sel<17> 0 0 NMOS_VTL L=50e-9 W='1*90e-9'
mn3274 col<10> sel<17> 0 0 NMOS_VTL L=50e-9 W='1*90e-9'
mn3275 col<11> sel<17> 0 0 NMOS_VTL L=50e-9 W='1*90e-9'
mn3277 col<13> sel<17> 0 0 NMOS_VTL L=50e-9 W='1*90e-9'
mn3278 col<14> sel<17> 0 0 NMOS_VTL L=50e-9 W='1*90e-9'
mn3279 col<15> sel<17> 0 0 NMOS_VTL L=50e-9 W='1*90e-9'
mn3280 col<16> sel<17> 0 0 NMOS_VTL L=50e-9 W='1*90e-9'
mn3281 col<17> sel<17> 0 0 NMOS_VTL L=50e-9 W='1*90e-9'
mn3285 col<21> sel<17> 0 0 NMOS_VTL L=50e-9 W='1*90e-9'
mn3286 col<22> sel<17> 0 0 NMOS_VTL L=50e-9 W='1*90e-9'
mn3287 col<23> sel<17> 0 0 NMOS_VTL L=50e-9 W='1*90e-9'
mn3288 col<24> sel<17> 0 0 NMOS_VTL L=50e-9 W='1*90e-9'
mn3289 col<25> sel<17> 0 0 NMOS_VTL L=50e-9 W='1*90e-9'
mn3290 col<26> sel<17> 0 0 NMOS_VTL L=50e-9 W='1*90e-9'
mn3291 col<27> sel<17> 0 0 NMOS_VTL L=50e-9 W='1*90e-9'
mn3292 col<28> sel<17> 0 0 NMOS_VTL L=50e-9 W='1*90e-9'
mn3293 col<29> sel<17> 0 0 NMOS_VTL L=50e-9 W='1*90e-9'
mn3297 col<33> sel<17> 0 0 NMOS_VTL L=50e-9 W='1*90e-9'
mn3303 col<39> sel<17> 0 0 NMOS_VTL L=50e-9 W='1*90e-9'
mn3304 col<40> sel<17> 0 0 NMOS_VTL L=50e-9 W='1*90e-9'
mn3305 col<41> sel<17> 0 0 NMOS_VTL L=50e-9 W='1*90e-9'
mn3307 col<43> sel<17> 0 0 NMOS_VTL L=50e-9 W='1*90e-9'
mn3308 col<44> sel<17> 0 0 NMOS_VTL L=50e-9 W='1*90e-9'
mn3310 col<46> sel<17> 0 0 NMOS_VTL L=50e-9 W='1*90e-9'
mn3311 col<47> sel<17> 0 0 NMOS_VTL L=50e-9 W='1*90e-9'
mn3312 col<48> sel<17> 0 0 NMOS_VTL L=50e-9 W='1*90e-9'
mn3313 col<49> sel<17> 0 0 NMOS_VTL L=50e-9 W='1*90e-9'
mn3314 col<50> sel<17> 0 0 NMOS_VTL L=50e-9 W='1*90e-9'
mn3315 col<51> sel<17> 0 0 NMOS_VTL L=50e-9 W='1*90e-9'
mn3316 col<52> sel<17> 0 0 NMOS_VTL L=50e-9 W='1*90e-9'
mn3317 col<53> sel<17> 0 0 NMOS_VTL L=50e-9 W='1*90e-9'
mn3318 col<54> sel<17> 0 0 NMOS_VTL L=50e-9 W='1*90e-9'
mn3319 col<55> sel<17> 0 0 NMOS_VTL L=50e-9 W='1*90e-9'
mn3320 col<56> sel<17> 0 0 NMOS_VTL L=50e-9 W='1*90e-9'
mn3321 col<57> sel<17> 0 0 NMOS_VTL L=50e-9 W='1*90e-9'
mn3322 col<58> sel<17> 0 0 NMOS_VTL L=50e-9 W='1*90e-9'
mn3323 col<59> sel<17> 0 0 NMOS_VTL L=50e-9 W='1*90e-9'
mn3324 col<60> sel<17> 0 0 NMOS_VTL L=50e-9 W='1*90e-9'
mn3325 col<61> sel<17> 0 0 NMOS_VTL L=50e-9 W='1*90e-9'
mn3330 col<66> sel<17> 0 0 NMOS_VTL L=50e-9 W='1*90e-9'
mn3331 col<67> sel<17> 0 0 NMOS_VTL L=50e-9 W='1*90e-9'
mn3332 col<68> sel<17> 0 0 NMOS_VTL L=50e-9 W='1*90e-9'
mn3334 col<70> sel<17> 0 0 NMOS_VTL L=50e-9 W='1*90e-9'
mn3335 col<71> sel<17> 0 0 NMOS_VTL L=50e-9 W='1*90e-9'
mn3336 col<72> sel<17> 0 0 NMOS_VTL L=50e-9 W='1*90e-9'
mn3337 col<73> sel<17> 0 0 NMOS_VTL L=50e-9 W='1*90e-9'
mn3338 col<74> sel<17> 0 0 NMOS_VTL L=50e-9 W='1*90e-9'
mn3343 col<79> sel<17> 0 0 NMOS_VTL L=50e-9 W='1*90e-9'
mn3344 col<80> sel<17> 0 0 NMOS_VTL L=50e-9 W='1*90e-9'
mn3346 col<82> sel<17> 0 0 NMOS_VTL L=50e-9 W='1*90e-9'
mn3347 col<83> sel<17> 0 0 NMOS_VTL L=50e-9 W='1*90e-9'
mn3348 col<84> sel<17> 0 0 NMOS_VTL L=50e-9 W='1*90e-9'
mn3349 col<85> sel<17> 0 0 NMOS_VTL L=50e-9 W='1*90e-9'
mn3351 col<87> sel<17> 0 0 NMOS_VTL L=50e-9 W='1*90e-9'
mn3352 col<88> sel<17> 0 0 NMOS_VTL L=50e-9 W='1*90e-9'
mn3353 col<89> sel<17> 0 0 NMOS_VTL L=50e-9 W='1*90e-9'
mn3355 col<91> sel<17> 0 0 NMOS_VTL L=50e-9 W='1*90e-9'
mn3356 col<92> sel<17> 0 0 NMOS_VTL L=50e-9 W='1*90e-9'
mn3358 col<94> sel<17> 0 0 NMOS_VTL L=50e-9 W='1*90e-9'
mn3359 col<95> sel<17> 0 0 NMOS_VTL L=50e-9 W='1*90e-9'
mn3360 col<96> sel<17> 0 0 NMOS_VTL L=50e-9 W='1*90e-9'
mn3361 col<97> sel<17> 0 0 NMOS_VTL L=50e-9 W='1*90e-9'
mn3362 col<98> sel<17> 0 0 NMOS_VTL L=50e-9 W='1*90e-9'
mn3363 col<99> sel<17> 0 0 NMOS_VTL L=50e-9 W='1*90e-9'
mn3364 col<100> sel<17> 0 0 NMOS_VTL L=50e-9 W='1*90e-9'
mn3365 col<101> sel<17> 0 0 NMOS_VTL L=50e-9 W='1*90e-9'
mn3366 col<102> sel<17> 0 0 NMOS_VTL L=50e-9 W='1*90e-9'
mn3368 col<104> sel<17> 0 0 NMOS_VTL L=50e-9 W='1*90e-9'
mn3369 col<105> sel<17> 0 0 NMOS_VTL L=50e-9 W='1*90e-9'
mn3370 col<106> sel<17> 0 0 NMOS_VTL L=50e-9 W='1*90e-9'
mn3371 col<107> sel<17> 0 0 NMOS_VTL L=50e-9 W='1*90e-9'
mn3372 col<108> sel<17> 0 0 NMOS_VTL L=50e-9 W='1*90e-9'
mn3378 col<114> sel<17> 0 0 NMOS_VTL L=50e-9 W='1*90e-9'
mn3379 col<115> sel<17> 0 0 NMOS_VTL L=50e-9 W='1*90e-9'
mn3380 col<116> sel<17> 0 0 NMOS_VTL L=50e-9 W='1*90e-9'
mn3384 col<120> sel<17> 0 0 NMOS_VTL L=50e-9 W='1*90e-9'
mn3385 col<121> sel<17> 0 0 NMOS_VTL L=50e-9 W='1*90e-9'
mn3386 col<122> sel<17> 0 0 NMOS_VTL L=50e-9 W='1*90e-9'
mn3387 col<123> sel<17> 0 0 NMOS_VTL L=50e-9 W='1*90e-9'
mn3388 col<124> sel<17> 0 0 NMOS_VTL L=50e-9 W='1*90e-9'
mn3389 col<125> sel<17> 0 0 NMOS_VTL L=50e-9 W='1*90e-9'
mn3391 col<127> sel<17> 0 0 NMOS_VTL L=50e-9 W='1*90e-9'
mn3392 col<128> sel<17> 0 0 NMOS_VTL L=50e-9 W='1*90e-9'
mn3393 col<129> sel<17> 0 0 NMOS_VTL L=50e-9 W='1*90e-9'
mn3394 col<130> sel<17> 0 0 NMOS_VTL L=50e-9 W='1*90e-9'
mn3395 col<131> sel<17> 0 0 NMOS_VTL L=50e-9 W='1*90e-9'
mn3405 col<141> sel<17> 0 0 NMOS_VTL L=50e-9 W='1*90e-9'
mn3406 col<142> sel<17> 0 0 NMOS_VTL L=50e-9 W='1*90e-9'
mn3407 col<143> sel<17> 0 0 NMOS_VTL L=50e-9 W='1*90e-9'
mn3411 col<147> sel<17> 0 0 NMOS_VTL L=50e-9 W='1*90e-9'
mn3412 col<148> sel<17> 0 0 NMOS_VTL L=50e-9 W='1*90e-9'
mn3413 col<149> sel<17> 0 0 NMOS_VTL L=50e-9 W='1*90e-9'
mn3414 col<150> sel<17> 0 0 NMOS_VTL L=50e-9 W='1*90e-9'
mn3417 col<153> sel<17> 0 0 NMOS_VTL L=50e-9 W='1*90e-9'
mn3418 col<154> sel<17> 0 0 NMOS_VTL L=50e-9 W='1*90e-9'
mn3419 col<155> sel<17> 0 0 NMOS_VTL L=50e-9 W='1*90e-9'
mn3426 col<162> sel<17> 0 0 NMOS_VTL L=50e-9 W='1*90e-9'
mn3427 col<163> sel<17> 0 0 NMOS_VTL L=50e-9 W='1*90e-9'
mn3428 col<164> sel<17> 0 0 NMOS_VTL L=50e-9 W='1*90e-9'
mn3430 col<166> sel<17> 0 0 NMOS_VTL L=50e-9 W='1*90e-9'
mn3431 col<167> sel<17> 0 0 NMOS_VTL L=50e-9 W='1*90e-9'
mn3435 col<171> sel<17> 0 0 NMOS_VTL L=50e-9 W='1*90e-9'
mn3436 col<172> sel<17> 0 0 NMOS_VTL L=50e-9 W='1*90e-9'
mn3437 col<173> sel<17> 0 0 NMOS_VTL L=50e-9 W='1*90e-9'
mn3444 col<180> sel<17> 0 0 NMOS_VTL L=50e-9 W='1*90e-9'
mn3445 col<181> sel<17> 0 0 NMOS_VTL L=50e-9 W='1*90e-9'
mn3446 col<182> sel<17> 0 0 NMOS_VTL L=50e-9 W='1*90e-9'
mn3447 col<183> sel<17> 0 0 NMOS_VTL L=50e-9 W='1*90e-9'
mn3448 col<184> sel<17> 0 0 NMOS_VTL L=50e-9 W='1*90e-9'
mn3449 col<185> sel<17> 0 0 NMOS_VTL L=50e-9 W='1*90e-9'
mn3450 col<186> sel<17> 0 0 NMOS_VTL L=50e-9 W='1*90e-9'
mn3451 col<187> sel<17> 0 0 NMOS_VTL L=50e-9 W='1*90e-9'
mn3452 col<188> sel<17> 0 0 NMOS_VTL L=50e-9 W='1*90e-9'
mn3454 col<190> sel<17> 0 0 NMOS_VTL L=50e-9 W='1*90e-9'
mn3455 col<191> sel<17> 0 0 NMOS_VTL L=50e-9 W='1*90e-9'
mn3456 col<0> sel<18> 0 0 NMOS_VTL L=50e-9 W='1*90e-9'
mn3457 col<1> sel<18> 0 0 NMOS_VTL L=50e-9 W='1*90e-9'
mn3458 col<2> sel<18> 0 0 NMOS_VTL L=50e-9 W='1*90e-9'
mn3462 col<6> sel<18> 0 0 NMOS_VTL L=50e-9 W='1*90e-9'
mn3463 col<7> sel<18> 0 0 NMOS_VTL L=50e-9 W='1*90e-9'
mn3464 col<8> sel<18> 0 0 NMOS_VTL L=50e-9 W='1*90e-9'
mn3468 col<12> sel<18> 0 0 NMOS_VTL L=50e-9 W='1*90e-9'
mn3469 col<13> sel<18> 0 0 NMOS_VTL L=50e-9 W='1*90e-9'
mn3470 col<14> sel<18> 0 0 NMOS_VTL L=50e-9 W='1*90e-9'
mn3471 col<15> sel<18> 0 0 NMOS_VTL L=50e-9 W='1*90e-9'
mn3472 col<16> sel<18> 0 0 NMOS_VTL L=50e-9 W='1*90e-9'
mn3473 col<17> sel<18> 0 0 NMOS_VTL L=50e-9 W='1*90e-9'
mn3486 col<30> sel<18> 0 0 NMOS_VTL L=50e-9 W='1*90e-9'
mn3487 col<31> sel<18> 0 0 NMOS_VTL L=50e-9 W='1*90e-9'
mn3488 col<32> sel<18> 0 0 NMOS_VTL L=50e-9 W='1*90e-9'
mn3492 col<36> sel<18> 0 0 NMOS_VTL L=50e-9 W='1*90e-9'
mn3495 col<39> sel<18> 0 0 NMOS_VTL L=50e-9 W='1*90e-9'
mn3496 col<40> sel<18> 0 0 NMOS_VTL L=50e-9 W='1*90e-9'
mn3497 col<41> sel<18> 0 0 NMOS_VTL L=50e-9 W='1*90e-9'
mn3498 col<42> sel<18> 0 0 NMOS_VTL L=50e-9 W='1*90e-9'
mn3499 col<43> sel<18> 0 0 NMOS_VTL L=50e-9 W='1*90e-9'
mn3500 col<44> sel<18> 0 0 NMOS_VTL L=50e-9 W='1*90e-9'
mn3504 col<48> sel<18> 0 0 NMOS_VTL L=50e-9 W='1*90e-9'
mn3505 col<49> sel<18> 0 0 NMOS_VTL L=50e-9 W='1*90e-9'
mn3506 col<50> sel<18> 0 0 NMOS_VTL L=50e-9 W='1*90e-9'
mn3507 col<51> sel<18> 0 0 NMOS_VTL L=50e-9 W='1*90e-9'
mn3508 col<52> sel<18> 0 0 NMOS_VTL L=50e-9 W='1*90e-9'
mn3509 col<53> sel<18> 0 0 NMOS_VTL L=50e-9 W='1*90e-9'
mn3513 col<57> sel<18> 0 0 NMOS_VTL L=50e-9 W='1*90e-9'
mn3514 col<58> sel<18> 0 0 NMOS_VTL L=50e-9 W='1*90e-9'
mn3515 col<59> sel<18> 0 0 NMOS_VTL L=50e-9 W='1*90e-9'
mn3516 col<60> sel<18> 0 0 NMOS_VTL L=50e-9 W='1*90e-9'
mn3519 col<63> sel<18> 0 0 NMOS_VTL L=50e-9 W='1*90e-9'
mn3525 col<69> sel<18> 0 0 NMOS_VTL L=50e-9 W='1*90e-9'
mn3526 col<70> sel<18> 0 0 NMOS_VTL L=50e-9 W='1*90e-9'
mn3527 col<71> sel<18> 0 0 NMOS_VTL L=50e-9 W='1*90e-9'
mn3528 col<72> sel<18> 0 0 NMOS_VTL L=50e-9 W='1*90e-9'
mn3529 col<73> sel<18> 0 0 NMOS_VTL L=50e-9 W='1*90e-9'
mn3530 col<74> sel<18> 0 0 NMOS_VTL L=50e-9 W='1*90e-9'
mn3537 col<81> sel<18> 0 0 NMOS_VTL L=50e-9 W='1*90e-9'
mn3538 col<82> sel<18> 0 0 NMOS_VTL L=50e-9 W='1*90e-9'
mn3539 col<83> sel<18> 0 0 NMOS_VTL L=50e-9 W='1*90e-9'
mn3543 col<87> sel<18> 0 0 NMOS_VTL L=50e-9 W='1*90e-9'
mn3544 col<88> sel<18> 0 0 NMOS_VTL L=50e-9 W='1*90e-9'
mn3545 col<89> sel<18> 0 0 NMOS_VTL L=50e-9 W='1*90e-9'
mn3555 col<99> sel<18> 0 0 NMOS_VTL L=50e-9 W='1*90e-9'
mn3556 col<100> sel<18> 0 0 NMOS_VTL L=50e-9 W='1*90e-9'
mn3557 col<101> sel<18> 0 0 NMOS_VTL L=50e-9 W='1*90e-9'
mn3561 col<105> sel<18> 0 0 NMOS_VTL L=50e-9 W='1*90e-9'
mn3562 col<106> sel<18> 0 0 NMOS_VTL L=50e-9 W='1*90e-9'
mn3563 col<107> sel<18> 0 0 NMOS_VTL L=50e-9 W='1*90e-9'
mn3564 col<108> sel<18> 0 0 NMOS_VTL L=50e-9 W='1*90e-9'
mn3565 col<109> sel<18> 0 0 NMOS_VTL L=50e-9 W='1*90e-9'
mn3566 col<110> sel<18> 0 0 NMOS_VTL L=50e-9 W='1*90e-9'
mn3573 col<117> sel<18> 0 0 NMOS_VTL L=50e-9 W='1*90e-9'
mn3574 col<118> sel<18> 0 0 NMOS_VTL L=50e-9 W='1*90e-9'
mn3575 col<119> sel<18> 0 0 NMOS_VTL L=50e-9 W='1*90e-9'
mn3576 col<120> sel<18> 0 0 NMOS_VTL L=50e-9 W='1*90e-9'
mn3577 col<121> sel<18> 0 0 NMOS_VTL L=50e-9 W='1*90e-9'
mn3578 col<122> sel<18> 0 0 NMOS_VTL L=50e-9 W='1*90e-9'
mn3579 col<123> sel<18> 0 0 NMOS_VTL L=50e-9 W='1*90e-9'
mn3582 col<126> sel<18> 0 0 NMOS_VTL L=50e-9 W='1*90e-9'
mn3585 col<129> sel<18> 0 0 NMOS_VTL L=50e-9 W='1*90e-9'
mn3586 col<130> sel<18> 0 0 NMOS_VTL L=50e-9 W='1*90e-9'
mn3587 col<131> sel<18> 0 0 NMOS_VTL L=50e-9 W='1*90e-9'
mn3594 col<138> sel<18> 0 0 NMOS_VTL L=50e-9 W='1*90e-9'
mn3595 col<139> sel<18> 0 0 NMOS_VTL L=50e-9 W='1*90e-9'
mn3596 col<140> sel<18> 0 0 NMOS_VTL L=50e-9 W='1*90e-9'
mn3600 col<144> sel<18> 0 0 NMOS_VTL L=50e-9 W='1*90e-9'
mn3601 col<145> sel<18> 0 0 NMOS_VTL L=50e-9 W='1*90e-9'
mn3602 col<146> sel<18> 0 0 NMOS_VTL L=50e-9 W='1*90e-9'
mn3603 col<147> sel<18> 0 0 NMOS_VTL L=50e-9 W='1*90e-9'
mn3604 col<148> sel<18> 0 0 NMOS_VTL L=50e-9 W='1*90e-9'
mn3605 col<149> sel<18> 0 0 NMOS_VTL L=50e-9 W='1*90e-9'
mn3609 col<153> sel<18> 0 0 NMOS_VTL L=50e-9 W='1*90e-9'
mn3615 col<159> sel<18> 0 0 NMOS_VTL L=50e-9 W='1*90e-9'
mn3616 col<160> sel<18> 0 0 NMOS_VTL L=50e-9 W='1*90e-9'
mn3617 col<161> sel<18> 0 0 NMOS_VTL L=50e-9 W='1*90e-9'
mn3624 col<168> sel<18> 0 0 NMOS_VTL L=50e-9 W='1*90e-9'
mn3625 col<169> sel<18> 0 0 NMOS_VTL L=50e-9 W='1*90e-9'
mn3626 col<170> sel<18> 0 0 NMOS_VTL L=50e-9 W='1*90e-9'
mn3627 col<171> sel<18> 0 0 NMOS_VTL L=50e-9 W='1*90e-9'
mn3628 col<172> sel<18> 0 0 NMOS_VTL L=50e-9 W='1*90e-9'
mn3629 col<173> sel<18> 0 0 NMOS_VTL L=50e-9 W='1*90e-9'
mn3633 col<177> sel<18> 0 0 NMOS_VTL L=50e-9 W='1*90e-9'
mn3634 col<178> sel<18> 0 0 NMOS_VTL L=50e-9 W='1*90e-9'
mn3635 col<179> sel<18> 0 0 NMOS_VTL L=50e-9 W='1*90e-9'
mn3636 col<180> sel<18> 0 0 NMOS_VTL L=50e-9 W='1*90e-9'
mn3637 col<181> sel<18> 0 0 NMOS_VTL L=50e-9 W='1*90e-9'
mn3638 col<182> sel<18> 0 0 NMOS_VTL L=50e-9 W='1*90e-9'
mn3642 col<186> sel<18> 0 0 NMOS_VTL L=50e-9 W='1*90e-9'
mn3643 col<187> sel<18> 0 0 NMOS_VTL L=50e-9 W='1*90e-9'
mn3644 col<188> sel<18> 0 0 NMOS_VTL L=50e-9 W='1*90e-9'
mn3648 col<0> sel<19> 0 0 NMOS_VTL L=50e-9 W='1*90e-9'
mn3649 col<1> sel<19> 0 0 NMOS_VTL L=50e-9 W='1*90e-9'
mn3650 col<2> sel<19> 0 0 NMOS_VTL L=50e-9 W='1*90e-9'
mn3651 col<3> sel<19> 0 0 NMOS_VTL L=50e-9 W='1*90e-9'
mn3652 col<4> sel<19> 0 0 NMOS_VTL L=50e-9 W='1*90e-9'
mn3653 col<5> sel<19> 0 0 NMOS_VTL L=50e-9 W='1*90e-9'
mn3657 col<9> sel<19> 0 0 NMOS_VTL L=50e-9 W='1*90e-9'
mn3658 col<10> sel<19> 0 0 NMOS_VTL L=50e-9 W='1*90e-9'
mn3659 col<11> sel<19> 0 0 NMOS_VTL L=50e-9 W='1*90e-9'
mn3666 col<18> sel<19> 0 0 NMOS_VTL L=50e-9 W='1*90e-9'
mn3667 col<19> sel<19> 0 0 NMOS_VTL L=50e-9 W='1*90e-9'
mn3668 col<20> sel<19> 0 0 NMOS_VTL L=50e-9 W='1*90e-9'
mn3669 col<21> sel<19> 0 0 NMOS_VTL L=50e-9 W='1*90e-9'
mn3670 col<22> sel<19> 0 0 NMOS_VTL L=50e-9 W='1*90e-9'
mn3671 col<23> sel<19> 0 0 NMOS_VTL L=50e-9 W='1*90e-9'
mn3672 col<24> sel<19> 0 0 NMOS_VTL L=50e-9 W='1*90e-9'
mn3673 col<25> sel<19> 0 0 NMOS_VTL L=50e-9 W='1*90e-9'
mn3674 col<26> sel<19> 0 0 NMOS_VTL L=50e-9 W='1*90e-9'
mn3675 col<27> sel<19> 0 0 NMOS_VTL L=50e-9 W='1*90e-9'
mn3676 col<28> sel<19> 0 0 NMOS_VTL L=50e-9 W='1*90e-9'
mn3677 col<29> sel<19> 0 0 NMOS_VTL L=50e-9 W='1*90e-9'
mn3678 col<30> sel<19> 0 0 NMOS_VTL L=50e-9 W='1*90e-9'
mn3681 col<33> sel<19> 0 0 NMOS_VTL L=50e-9 W='1*90e-9'
mn3682 col<34> sel<19> 0 0 NMOS_VTL L=50e-9 W='1*90e-9'
mn3684 col<36> sel<19> 0 0 NMOS_VTL L=50e-9 W='1*90e-9'
mn3690 col<42> sel<19> 0 0 NMOS_VTL L=50e-9 W='1*90e-9'
mn3691 col<43> sel<19> 0 0 NMOS_VTL L=50e-9 W='1*90e-9'
mn3692 col<44> sel<19> 0 0 NMOS_VTL L=50e-9 W='1*90e-9'
mn3693 col<45> sel<19> 0 0 NMOS_VTL L=50e-9 W='1*90e-9'
mn3694 col<46> sel<19> 0 0 NMOS_VTL L=50e-9 W='1*90e-9'
mn3695 col<47> sel<19> 0 0 NMOS_VTL L=50e-9 W='1*90e-9'
mn3696 col<48> sel<19> 0 0 NMOS_VTL L=50e-9 W='1*90e-9'
mn3697 col<49> sel<19> 0 0 NMOS_VTL L=50e-9 W='1*90e-9'
mn3698 col<50> sel<19> 0 0 NMOS_VTL L=50e-9 W='1*90e-9'
mn3706 col<58> sel<19> 0 0 NMOS_VTL L=50e-9 W='1*90e-9'
mn3707 col<59> sel<19> 0 0 NMOS_VTL L=50e-9 W='1*90e-9'
mn3715 col<67> sel<19> 0 0 NMOS_VTL L=50e-9 W='1*90e-9'
mn3716 col<68> sel<19> 0 0 NMOS_VTL L=50e-9 W='1*90e-9'
mn3718 col<70> sel<19> 0 0 NMOS_VTL L=50e-9 W='1*90e-9'
mn3719 col<71> sel<19> 0 0 NMOS_VTL L=50e-9 W='1*90e-9'
mn3720 col<72> sel<19> 0 0 NMOS_VTL L=50e-9 W='1*90e-9'
mn3721 col<73> sel<19> 0 0 NMOS_VTL L=50e-9 W='1*90e-9'
mn3722 col<74> sel<19> 0 0 NMOS_VTL L=50e-9 W='1*90e-9'
mn3724 col<76> sel<19> 0 0 NMOS_VTL L=50e-9 W='1*90e-9'
mn3725 col<77> sel<19> 0 0 NMOS_VTL L=50e-9 W='1*90e-9'
mn3726 col<78> sel<19> 0 0 NMOS_VTL L=50e-9 W='1*90e-9'
mn3728 col<80> sel<19> 0 0 NMOS_VTL L=50e-9 W='1*90e-9'
mn3729 col<81> sel<19> 0 0 NMOS_VTL L=50e-9 W='1*90e-9'
mn3730 col<82> sel<19> 0 0 NMOS_VTL L=50e-9 W='1*90e-9'
mn3731 col<83> sel<19> 0 0 NMOS_VTL L=50e-9 W='1*90e-9'
mn3741 col<93> sel<19> 0 0 NMOS_VTL L=50e-9 W='1*90e-9'
mn3742 col<94> sel<19> 0 0 NMOS_VTL L=50e-9 W='1*90e-9'
mn3743 col<95> sel<19> 0 0 NMOS_VTL L=50e-9 W='1*90e-9'
mn3744 col<96> sel<19> 0 0 NMOS_VTL L=50e-9 W='1*90e-9'
mn3745 col<97> sel<19> 0 0 NMOS_VTL L=50e-9 W='1*90e-9'
mn3746 col<98> sel<19> 0 0 NMOS_VTL L=50e-9 W='1*90e-9'
mn3747 col<99> sel<19> 0 0 NMOS_VTL L=50e-9 W='1*90e-9'
mn3748 col<100> sel<19> 0 0 NMOS_VTL L=50e-9 W='1*90e-9'
mn3749 col<101> sel<19> 0 0 NMOS_VTL L=50e-9 W='1*90e-9'
mn3750 col<102> sel<19> 0 0 NMOS_VTL L=50e-9 W='1*90e-9'
mn3751 col<103> sel<19> 0 0 NMOS_VTL L=50e-9 W='1*90e-9'
mn3752 col<104> sel<19> 0 0 NMOS_VTL L=50e-9 W='1*90e-9'
mn3753 col<105> sel<19> 0 0 NMOS_VTL L=50e-9 W='1*90e-9'
mn3759 col<111> sel<19> 0 0 NMOS_VTL L=50e-9 W='1*90e-9'
mn3762 col<114> sel<19> 0 0 NMOS_VTL L=50e-9 W='1*90e-9'
mn3768 col<120> sel<19> 0 0 NMOS_VTL L=50e-9 W='1*90e-9'
mn3769 col<121> sel<19> 0 0 NMOS_VTL L=50e-9 W='1*90e-9'
mn3770 col<122> sel<19> 0 0 NMOS_VTL L=50e-9 W='1*90e-9'
mn3775 col<127> sel<19> 0 0 NMOS_VTL L=50e-9 W='1*90e-9'
mn3778 col<130> sel<19> 0 0 NMOS_VTL L=50e-9 W='1*90e-9'
mn3780 col<132> sel<19> 0 0 NMOS_VTL L=50e-9 W='1*90e-9'
mn3784 col<136> sel<19> 0 0 NMOS_VTL L=50e-9 W='1*90e-9'
mn3789 col<141> sel<19> 0 0 NMOS_VTL L=50e-9 W='1*90e-9'
mn3790 col<142> sel<19> 0 0 NMOS_VTL L=50e-9 W='1*90e-9'
mn3791 col<143> sel<19> 0 0 NMOS_VTL L=50e-9 W='1*90e-9'
mn3795 col<147> sel<19> 0 0 NMOS_VTL L=50e-9 W='1*90e-9'
mn3796 col<148> sel<19> 0 0 NMOS_VTL L=50e-9 W='1*90e-9'
mn3797 col<149> sel<19> 0 0 NMOS_VTL L=50e-9 W='1*90e-9'
mn3810 col<162> sel<19> 0 0 NMOS_VTL L=50e-9 W='1*90e-9'
mn3811 col<163> sel<19> 0 0 NMOS_VTL L=50e-9 W='1*90e-9'
mn3812 col<164> sel<19> 0 0 NMOS_VTL L=50e-9 W='1*90e-9'
mn3813 col<165> sel<19> 0 0 NMOS_VTL L=50e-9 W='1*90e-9'
mn3814 col<166> sel<19> 0 0 NMOS_VTL L=50e-9 W='1*90e-9'
mn3815 col<167> sel<19> 0 0 NMOS_VTL L=50e-9 W='1*90e-9'
mn3819 col<171> sel<19> 0 0 NMOS_VTL L=50e-9 W='1*90e-9'
mn3820 col<172> sel<19> 0 0 NMOS_VTL L=50e-9 W='1*90e-9'
mn3821 col<173> sel<19> 0 0 NMOS_VTL L=50e-9 W='1*90e-9'
mn3825 col<177> sel<19> 0 0 NMOS_VTL L=50e-9 W='1*90e-9'
mn3826 col<178> sel<19> 0 0 NMOS_VTL L=50e-9 W='1*90e-9'
mn3827 col<179> sel<19> 0 0 NMOS_VTL L=50e-9 W='1*90e-9'
mn3828 col<180> sel<19> 0 0 NMOS_VTL L=50e-9 W='1*90e-9'
mn3829 col<181> sel<19> 0 0 NMOS_VTL L=50e-9 W='1*90e-9'
mn3830 col<182> sel<19> 0 0 NMOS_VTL L=50e-9 W='1*90e-9'
mn3834 col<186> sel<19> 0 0 NMOS_VTL L=50e-9 W='1*90e-9'
mn3835 col<187> sel<19> 0 0 NMOS_VTL L=50e-9 W='1*90e-9'
mn3836 col<188> sel<19> 0 0 NMOS_VTL L=50e-9 W='1*90e-9'
mn3840 col<0> sel<20> 0 0 NMOS_VTL L=50e-9 W='1*90e-9'
mn3841 col<1> sel<20> 0 0 NMOS_VTL L=50e-9 W='1*90e-9'
mn3842 col<2> sel<20> 0 0 NMOS_VTL L=50e-9 W='1*90e-9'
mn3843 col<3> sel<20> 0 0 NMOS_VTL L=50e-9 W='1*90e-9'
mn3844 col<4> sel<20> 0 0 NMOS_VTL L=50e-9 W='1*90e-9'
mn3845 col<5> sel<20> 0 0 NMOS_VTL L=50e-9 W='1*90e-9'
mn3846 col<6> sel<20> 0 0 NMOS_VTL L=50e-9 W='1*90e-9'
mn3847 col<7> sel<20> 0 0 NMOS_VTL L=50e-9 W='1*90e-9'
mn3848 col<8> sel<20> 0 0 NMOS_VTL L=50e-9 W='1*90e-9'
mn3849 col<9> sel<20> 0 0 NMOS_VTL L=50e-9 W='1*90e-9'
mn3850 col<10> sel<20> 0 0 NMOS_VTL L=50e-9 W='1*90e-9'
mn3851 col<11> sel<20> 0 0 NMOS_VTL L=50e-9 W='1*90e-9'
mn3853 col<13> sel<20> 0 0 NMOS_VTL L=50e-9 W='1*90e-9'
mn3854 col<14> sel<20> 0 0 NMOS_VTL L=50e-9 W='1*90e-9'
mn3855 col<15> sel<20> 0 0 NMOS_VTL L=50e-9 W='1*90e-9'
mn3856 col<16> sel<20> 0 0 NMOS_VTL L=50e-9 W='1*90e-9'
mn3857 col<17> sel<20> 0 0 NMOS_VTL L=50e-9 W='1*90e-9'
mn3858 col<18> sel<20> 0 0 NMOS_VTL L=50e-9 W='1*90e-9'
mn3859 col<19> sel<20> 0 0 NMOS_VTL L=50e-9 W='1*90e-9'
mn3860 col<20> sel<20> 0 0 NMOS_VTL L=50e-9 W='1*90e-9'
mn3861 col<21> sel<20> 0 0 NMOS_VTL L=50e-9 W='1*90e-9'
mn3862 col<22> sel<20> 0 0 NMOS_VTL L=50e-9 W='1*90e-9'
mn3863 col<23> sel<20> 0 0 NMOS_VTL L=50e-9 W='1*90e-9'
mn3867 col<27> sel<20> 0 0 NMOS_VTL L=50e-9 W='1*90e-9'
mn3868 col<28> sel<20> 0 0 NMOS_VTL L=50e-9 W='1*90e-9'
mn3869 col<29> sel<20> 0 0 NMOS_VTL L=50e-9 W='1*90e-9'
mn3870 col<30> sel<20> 0 0 NMOS_VTL L=50e-9 W='1*90e-9'
mn3871 col<31> sel<20> 0 0 NMOS_VTL L=50e-9 W='1*90e-9'
mn3872 col<32> sel<20> 0 0 NMOS_VTL L=50e-9 W='1*90e-9'
mn3873 col<33> sel<20> 0 0 NMOS_VTL L=50e-9 W='1*90e-9'
mn3874 col<34> sel<20> 0 0 NMOS_VTL L=50e-9 W='1*90e-9'
mn3875 col<35> sel<20> 0 0 NMOS_VTL L=50e-9 W='1*90e-9'
mn3879 col<39> sel<20> 0 0 NMOS_VTL L=50e-9 W='1*90e-9'
mn3882 col<42> sel<20> 0 0 NMOS_VTL L=50e-9 W='1*90e-9'
mn3883 col<43> sel<20> 0 0 NMOS_VTL L=50e-9 W='1*90e-9'
mn3884 col<44> sel<20> 0 0 NMOS_VTL L=50e-9 W='1*90e-9'
mn3888 col<48> sel<20> 0 0 NMOS_VTL L=50e-9 W='1*90e-9'
mn3889 col<49> sel<20> 0 0 NMOS_VTL L=50e-9 W='1*90e-9'
mn3890 col<50> sel<20> 0 0 NMOS_VTL L=50e-9 W='1*90e-9'
mn3891 col<51> sel<20> 0 0 NMOS_VTL L=50e-9 W='1*90e-9'
mn3892 col<52> sel<20> 0 0 NMOS_VTL L=50e-9 W='1*90e-9'
mn3893 col<53> sel<20> 0 0 NMOS_VTL L=50e-9 W='1*90e-9'
mn3901 col<61> sel<20> 0 0 NMOS_VTL L=50e-9 W='1*90e-9'
mn3902 col<62> sel<20> 0 0 NMOS_VTL L=50e-9 W='1*90e-9'
mn3909 col<69> sel<20> 0 0 NMOS_VTL L=50e-9 W='1*90e-9'
mn3910 col<70> sel<20> 0 0 NMOS_VTL L=50e-9 W='1*90e-9'
mn3911 col<71> sel<20> 0 0 NMOS_VTL L=50e-9 W='1*90e-9'
mn3912 col<72> sel<20> 0 0 NMOS_VTL L=50e-9 W='1*90e-9'
mn3913 col<73> sel<20> 0 0 NMOS_VTL L=50e-9 W='1*90e-9'
mn3914 col<74> sel<20> 0 0 NMOS_VTL L=50e-9 W='1*90e-9'
mn3915 col<75> sel<20> 0 0 NMOS_VTL L=50e-9 W='1*90e-9'
mn3916 col<76> sel<20> 0 0 NMOS_VTL L=50e-9 W='1*90e-9'
mn3917 col<77> sel<20> 0 0 NMOS_VTL L=50e-9 W='1*90e-9'
mn3922 col<82> sel<20> 0 0 NMOS_VTL L=50e-9 W='1*90e-9'
mn3924 col<84> sel<20> 0 0 NMOS_VTL L=50e-9 W='1*90e-9'
mn3925 col<85> sel<20> 0 0 NMOS_VTL L=50e-9 W='1*90e-9'
mn3930 col<90> sel<20> 0 0 NMOS_VTL L=50e-9 W='1*90e-9'
mn3931 col<91> sel<20> 0 0 NMOS_VTL L=50e-9 W='1*90e-9'
mn3932 col<92> sel<20> 0 0 NMOS_VTL L=50e-9 W='1*90e-9'
mn3933 col<93> sel<20> 0 0 NMOS_VTL L=50e-9 W='1*90e-9'
mn3934 col<94> sel<20> 0 0 NMOS_VTL L=50e-9 W='1*90e-9'
mn3935 col<95> sel<20> 0 0 NMOS_VTL L=50e-9 W='1*90e-9'
mn3936 col<96> sel<20> 0 0 NMOS_VTL L=50e-9 W='1*90e-9'
mn3937 col<97> sel<20> 0 0 NMOS_VTL L=50e-9 W='1*90e-9'
mn3938 col<98> sel<20> 0 0 NMOS_VTL L=50e-9 W='1*90e-9'
mn3942 col<102> sel<20> 0 0 NMOS_VTL L=50e-9 W='1*90e-9'
mn3943 col<103> sel<20> 0 0 NMOS_VTL L=50e-9 W='1*90e-9'
mn3944 col<104> sel<20> 0 0 NMOS_VTL L=50e-9 W='1*90e-9'
mn3945 col<105> sel<20> 0 0 NMOS_VTL L=50e-9 W='1*90e-9'
mn3946 col<106> sel<20> 0 0 NMOS_VTL L=50e-9 W='1*90e-9'
mn3948 col<108> sel<20> 0 0 NMOS_VTL L=50e-9 W='1*90e-9'
mn3949 col<109> sel<20> 0 0 NMOS_VTL L=50e-9 W='1*90e-9'
mn3951 col<111> sel<20> 0 0 NMOS_VTL L=50e-9 W='1*90e-9'
mn3952 col<112> sel<20> 0 0 NMOS_VTL L=50e-9 W='1*90e-9'
mn3953 col<113> sel<20> 0 0 NMOS_VTL L=50e-9 W='1*90e-9'
mn3955 col<115> sel<20> 0 0 NMOS_VTL L=50e-9 W='1*90e-9'
mn3956 col<116> sel<20> 0 0 NMOS_VTL L=50e-9 W='1*90e-9'
mn3958 col<118> sel<20> 0 0 NMOS_VTL L=50e-9 W='1*90e-9'
mn3959 col<119> sel<20> 0 0 NMOS_VTL L=50e-9 W='1*90e-9'
mn3961 col<121> sel<20> 0 0 NMOS_VTL L=50e-9 W='1*90e-9'
mn3962 col<122> sel<20> 0 0 NMOS_VTL L=50e-9 W='1*90e-9'
mn3964 col<124> sel<20> 0 0 NMOS_VTL L=50e-9 W='1*90e-9'
mn3965 col<125> sel<20> 0 0 NMOS_VTL L=50e-9 W='1*90e-9'
mn3966 col<126> sel<20> 0 0 NMOS_VTL L=50e-9 W='1*90e-9'
mn3967 col<127> sel<20> 0 0 NMOS_VTL L=50e-9 W='1*90e-9'
mn3968 col<128> sel<20> 0 0 NMOS_VTL L=50e-9 W='1*90e-9'
mn3970 col<130> sel<20> 0 0 NMOS_VTL L=50e-9 W='1*90e-9'
mn3971 col<131> sel<20> 0 0 NMOS_VTL L=50e-9 W='1*90e-9'
mn3972 col<132> sel<20> 0 0 NMOS_VTL L=50e-9 W='1*90e-9'
mn3973 col<133> sel<20> 0 0 NMOS_VTL L=50e-9 W='1*90e-9'
mn3974 col<134> sel<20> 0 0 NMOS_VTL L=50e-9 W='1*90e-9'
mn3976 col<136> sel<20> 0 0 NMOS_VTL L=50e-9 W='1*90e-9'
mn3977 col<137> sel<20> 0 0 NMOS_VTL L=50e-9 W='1*90e-9'
mn3978 col<138> sel<20> 0 0 NMOS_VTL L=50e-9 W='1*90e-9'
mn3979 col<139> sel<20> 0 0 NMOS_VTL L=50e-9 W='1*90e-9'
mn3980 col<140> sel<20> 0 0 NMOS_VTL L=50e-9 W='1*90e-9'
mn3981 col<141> sel<20> 0 0 NMOS_VTL L=50e-9 W='1*90e-9'
mn3982 col<142> sel<20> 0 0 NMOS_VTL L=50e-9 W='1*90e-9'
mn3983 col<143> sel<20> 0 0 NMOS_VTL L=50e-9 W='1*90e-9'
mn3984 col<144> sel<20> 0 0 NMOS_VTL L=50e-9 W='1*90e-9'
mn3985 col<145> sel<20> 0 0 NMOS_VTL L=50e-9 W='1*90e-9'
mn3986 col<146> sel<20> 0 0 NMOS_VTL L=50e-9 W='1*90e-9'
mn3996 col<156> sel<20> 0 0 NMOS_VTL L=50e-9 W='1*90e-9'
mn4002 col<162> sel<20> 0 0 NMOS_VTL L=50e-9 W='1*90e-9'
mn4003 col<163> sel<20> 0 0 NMOS_VTL L=50e-9 W='1*90e-9'
mn4004 col<164> sel<20> 0 0 NMOS_VTL L=50e-9 W='1*90e-9'
mn4008 col<168> sel<20> 0 0 NMOS_VTL L=50e-9 W='1*90e-9'
mn4009 col<169> sel<20> 0 0 NMOS_VTL L=50e-9 W='1*90e-9'
mn4010 col<170> sel<20> 0 0 NMOS_VTL L=50e-9 W='1*90e-9'
mn4011 col<171> sel<20> 0 0 NMOS_VTL L=50e-9 W='1*90e-9'
mn4012 col<172> sel<20> 0 0 NMOS_VTL L=50e-9 W='1*90e-9'
mn4013 col<173> sel<20> 0 0 NMOS_VTL L=50e-9 W='1*90e-9'
mn4014 col<174> sel<20> 0 0 NMOS_VTL L=50e-9 W='1*90e-9'
mn4015 col<175> sel<20> 0 0 NMOS_VTL L=50e-9 W='1*90e-9'
mn4016 col<176> sel<20> 0 0 NMOS_VTL L=50e-9 W='1*90e-9'
mn4017 col<177> sel<20> 0 0 NMOS_VTL L=50e-9 W='1*90e-9'
mn4018 col<178> sel<20> 0 0 NMOS_VTL L=50e-9 W='1*90e-9'
mn4019 col<179> sel<20> 0 0 NMOS_VTL L=50e-9 W='1*90e-9'
mn4029 col<189> sel<20> 0 0 NMOS_VTL L=50e-9 W='1*90e-9'
mn4030 col<190> sel<20> 0 0 NMOS_VTL L=50e-9 W='1*90e-9'
mn4031 col<191> sel<20> 0 0 NMOS_VTL L=50e-9 W='1*90e-9'
mn4035 col<3> sel<21> 0 0 NMOS_VTL L=50e-9 W='1*90e-9'
mn4036 col<4> sel<21> 0 0 NMOS_VTL L=50e-9 W='1*90e-9'
mn4037 col<5> sel<21> 0 0 NMOS_VTL L=50e-9 W='1*90e-9'
mn4038 col<6> sel<21> 0 0 NMOS_VTL L=50e-9 W='1*90e-9'
mn4039 col<7> sel<21> 0 0 NMOS_VTL L=50e-9 W='1*90e-9'
mn4040 col<8> sel<21> 0 0 NMOS_VTL L=50e-9 W='1*90e-9'
mn4041 col<9> sel<21> 0 0 NMOS_VTL L=50e-9 W='1*90e-9'
mn4042 col<10> sel<21> 0 0 NMOS_VTL L=50e-9 W='1*90e-9'
mn4043 col<11> sel<21> 0 0 NMOS_VTL L=50e-9 W='1*90e-9'
mn4044 col<12> sel<21> 0 0 NMOS_VTL L=50e-9 W='1*90e-9'
mn4045 col<13> sel<21> 0 0 NMOS_VTL L=50e-9 W='1*90e-9'
mn4046 col<14> sel<21> 0 0 NMOS_VTL L=50e-9 W='1*90e-9'
mn4047 col<15> sel<21> 0 0 NMOS_VTL L=50e-9 W='1*90e-9'
mn4048 col<16> sel<21> 0 0 NMOS_VTL L=50e-9 W='1*90e-9'
mn4049 col<17> sel<21> 0 0 NMOS_VTL L=50e-9 W='1*90e-9'
mn4050 col<18> sel<21> 0 0 NMOS_VTL L=50e-9 W='1*90e-9'
mn4051 col<19> sel<21> 0 0 NMOS_VTL L=50e-9 W='1*90e-9'
mn4052 col<20> sel<21> 0 0 NMOS_VTL L=50e-9 W='1*90e-9'
mn4053 col<21> sel<21> 0 0 NMOS_VTL L=50e-9 W='1*90e-9'
mn4054 col<22> sel<21> 0 0 NMOS_VTL L=50e-9 W='1*90e-9'
mn4055 col<23> sel<21> 0 0 NMOS_VTL L=50e-9 W='1*90e-9'
mn4063 col<31> sel<21> 0 0 NMOS_VTL L=50e-9 W='1*90e-9'
mn4064 col<32> sel<21> 0 0 NMOS_VTL L=50e-9 W='1*90e-9'
mn4065 col<33> sel<21> 0 0 NMOS_VTL L=50e-9 W='1*90e-9'
mn4066 col<34> sel<21> 0 0 NMOS_VTL L=50e-9 W='1*90e-9'
mn4067 col<35> sel<21> 0 0 NMOS_VTL L=50e-9 W='1*90e-9'
mn4071 col<39> sel<21> 0 0 NMOS_VTL L=50e-9 W='1*90e-9'
mn4072 col<40> sel<21> 0 0 NMOS_VTL L=50e-9 W='1*90e-9'
mn4073 col<41> sel<21> 0 0 NMOS_VTL L=50e-9 W='1*90e-9'
mn4074 col<42> sel<21> 0 0 NMOS_VTL L=50e-9 W='1*90e-9'
mn4075 col<43> sel<21> 0 0 NMOS_VTL L=50e-9 W='1*90e-9'
mn4076 col<44> sel<21> 0 0 NMOS_VTL L=50e-9 W='1*90e-9'
mn4077 col<45> sel<21> 0 0 NMOS_VTL L=50e-9 W='1*90e-9'
mn4078 col<46> sel<21> 0 0 NMOS_VTL L=50e-9 W='1*90e-9'
mn4079 col<47> sel<21> 0 0 NMOS_VTL L=50e-9 W='1*90e-9'
mn4080 col<48> sel<21> 0 0 NMOS_VTL L=50e-9 W='1*90e-9'
mn4081 col<49> sel<21> 0 0 NMOS_VTL L=50e-9 W='1*90e-9'
mn4082 col<50> sel<21> 0 0 NMOS_VTL L=50e-9 W='1*90e-9'
mn4083 col<51> sel<21> 0 0 NMOS_VTL L=50e-9 W='1*90e-9'
mn4084 col<52> sel<21> 0 0 NMOS_VTL L=50e-9 W='1*90e-9'
mn4085 col<53> sel<21> 0 0 NMOS_VTL L=50e-9 W='1*90e-9'
mn4087 col<55> sel<21> 0 0 NMOS_VTL L=50e-9 W='1*90e-9'
mn4088 col<56> sel<21> 0 0 NMOS_VTL L=50e-9 W='1*90e-9'
mn4089 col<57> sel<21> 0 0 NMOS_VTL L=50e-9 W='1*90e-9'
mn4090 col<58> sel<21> 0 0 NMOS_VTL L=50e-9 W='1*90e-9'
mn4091 col<59> sel<21> 0 0 NMOS_VTL L=50e-9 W='1*90e-9'
mn4095 col<63> sel<21> 0 0 NMOS_VTL L=50e-9 W='1*90e-9'
mn4096 col<64> sel<21> 0 0 NMOS_VTL L=50e-9 W='1*90e-9'
mn4097 col<65> sel<21> 0 0 NMOS_VTL L=50e-9 W='1*90e-9'
mn4098 col<66> sel<21> 0 0 NMOS_VTL L=50e-9 W='1*90e-9'
mn4099 col<67> sel<21> 0 0 NMOS_VTL L=50e-9 W='1*90e-9'
mn4100 col<68> sel<21> 0 0 NMOS_VTL L=50e-9 W='1*90e-9'
mn4101 col<69> sel<21> 0 0 NMOS_VTL L=50e-9 W='1*90e-9'
mn4102 col<70> sel<21> 0 0 NMOS_VTL L=50e-9 W='1*90e-9'
mn4103 col<71> sel<21> 0 0 NMOS_VTL L=50e-9 W='1*90e-9'
mn4104 col<72> sel<21> 0 0 NMOS_VTL L=50e-9 W='1*90e-9'
mn4105 col<73> sel<21> 0 0 NMOS_VTL L=50e-9 W='1*90e-9'
mn4106 col<74> sel<21> 0 0 NMOS_VTL L=50e-9 W='1*90e-9'
mn4111 col<79> sel<21> 0 0 NMOS_VTL L=50e-9 W='1*90e-9'
mn4116 col<84> sel<21> 0 0 NMOS_VTL L=50e-9 W='1*90e-9'
mn4117 col<85> sel<21> 0 0 NMOS_VTL L=50e-9 W='1*90e-9'
mn4118 col<86> sel<21> 0 0 NMOS_VTL L=50e-9 W='1*90e-9'
mn4122 col<90> sel<21> 0 0 NMOS_VTL L=50e-9 W='1*90e-9'
mn4125 col<93> sel<21> 0 0 NMOS_VTL L=50e-9 W='1*90e-9'
mn4126 col<94> sel<21> 0 0 NMOS_VTL L=50e-9 W='1*90e-9'
mn4127 col<95> sel<21> 0 0 NMOS_VTL L=50e-9 W='1*90e-9'
mn4128 col<96> sel<21> 0 0 NMOS_VTL L=50e-9 W='1*90e-9'
mn4129 col<97> sel<21> 0 0 NMOS_VTL L=50e-9 W='1*90e-9'
mn4130 col<98> sel<21> 0 0 NMOS_VTL L=50e-9 W='1*90e-9'
mn4134 col<102> sel<21> 0 0 NMOS_VTL L=50e-9 W='1*90e-9'
mn4135 col<103> sel<21> 0 0 NMOS_VTL L=50e-9 W='1*90e-9'
mn4140 col<108> sel<21> 0 0 NMOS_VTL L=50e-9 W='1*90e-9'
mn4141 col<109> sel<21> 0 0 NMOS_VTL L=50e-9 W='1*90e-9'
mn4142 col<110> sel<21> 0 0 NMOS_VTL L=50e-9 W='1*90e-9'
mn4143 col<111> sel<21> 0 0 NMOS_VTL L=50e-9 W='1*90e-9'
mn4146 col<114> sel<21> 0 0 NMOS_VTL L=50e-9 W='1*90e-9'
mn4149 col<117> sel<21> 0 0 NMOS_VTL L=50e-9 W='1*90e-9'
mn4150 col<118> sel<21> 0 0 NMOS_VTL L=50e-9 W='1*90e-9'
mn4151 col<119> sel<21> 0 0 NMOS_VTL L=50e-9 W='1*90e-9'
mn4152 col<120> sel<21> 0 0 NMOS_VTL L=50e-9 W='1*90e-9'
mn4153 col<121> sel<21> 0 0 NMOS_VTL L=50e-9 W='1*90e-9'
mn4154 col<122> sel<21> 0 0 NMOS_VTL L=50e-9 W='1*90e-9'
mn4155 col<123> sel<21> 0 0 NMOS_VTL L=50e-9 W='1*90e-9'
mn4156 col<124> sel<21> 0 0 NMOS_VTL L=50e-9 W='1*90e-9'
mn4157 col<125> sel<21> 0 0 NMOS_VTL L=50e-9 W='1*90e-9'
mn4167 col<135> sel<21> 0 0 NMOS_VTL L=50e-9 W='1*90e-9'
mn4170 col<138> sel<21> 0 0 NMOS_VTL L=50e-9 W='1*90e-9'
mn4171 col<139> sel<21> 0 0 NMOS_VTL L=50e-9 W='1*90e-9'
mn4172 col<140> sel<21> 0 0 NMOS_VTL L=50e-9 W='1*90e-9'
mn4173 col<141> sel<21> 0 0 NMOS_VTL L=50e-9 W='1*90e-9'
mn4174 col<142> sel<21> 0 0 NMOS_VTL L=50e-9 W='1*90e-9'
mn4175 col<143> sel<21> 0 0 NMOS_VTL L=50e-9 W='1*90e-9'
mn4176 col<144> sel<21> 0 0 NMOS_VTL L=50e-9 W='1*90e-9'
mn4177 col<145> sel<21> 0 0 NMOS_VTL L=50e-9 W='1*90e-9'
mn4178 col<146> sel<21> 0 0 NMOS_VTL L=50e-9 W='1*90e-9'
mn4179 col<147> sel<21> 0 0 NMOS_VTL L=50e-9 W='1*90e-9'
mn4180 col<148> sel<21> 0 0 NMOS_VTL L=50e-9 W='1*90e-9'
mn4181 col<149> sel<21> 0 0 NMOS_VTL L=50e-9 W='1*90e-9'
mn4182 col<150> sel<21> 0 0 NMOS_VTL L=50e-9 W='1*90e-9'
mn4183 col<151> sel<21> 0 0 NMOS_VTL L=50e-9 W='1*90e-9'
mn4184 col<152> sel<21> 0 0 NMOS_VTL L=50e-9 W='1*90e-9'
mn4194 col<162> sel<21> 0 0 NMOS_VTL L=50e-9 W='1*90e-9'
mn4195 col<163> sel<21> 0 0 NMOS_VTL L=50e-9 W='1*90e-9'
mn4196 col<164> sel<21> 0 0 NMOS_VTL L=50e-9 W='1*90e-9'
mn4197 col<165> sel<21> 0 0 NMOS_VTL L=50e-9 W='1*90e-9'
mn4198 col<166> sel<21> 0 0 NMOS_VTL L=50e-9 W='1*90e-9'
mn4199 col<167> sel<21> 0 0 NMOS_VTL L=50e-9 W='1*90e-9'
mn4203 col<171> sel<21> 0 0 NMOS_VTL L=50e-9 W='1*90e-9'
mn4204 col<172> sel<21> 0 0 NMOS_VTL L=50e-9 W='1*90e-9'
mn4205 col<173> sel<21> 0 0 NMOS_VTL L=50e-9 W='1*90e-9'
mn4206 col<174> sel<21> 0 0 NMOS_VTL L=50e-9 W='1*90e-9'
mn4207 col<175> sel<21> 0 0 NMOS_VTL L=50e-9 W='1*90e-9'
mn4208 col<176> sel<21> 0 0 NMOS_VTL L=50e-9 W='1*90e-9'
mn4209 col<177> sel<21> 0 0 NMOS_VTL L=50e-9 W='1*90e-9'
mn4210 col<178> sel<21> 0 0 NMOS_VTL L=50e-9 W='1*90e-9'
mn4211 col<179> sel<21> 0 0 NMOS_VTL L=50e-9 W='1*90e-9'
mn4212 col<180> sel<21> 0 0 NMOS_VTL L=50e-9 W='1*90e-9'
mn4213 col<181> sel<21> 0 0 NMOS_VTL L=50e-9 W='1*90e-9'
mn4214 col<182> sel<21> 0 0 NMOS_VTL L=50e-9 W='1*90e-9'
mn4215 col<183> sel<21> 0 0 NMOS_VTL L=50e-9 W='1*90e-9'
mn4216 col<184> sel<21> 0 0 NMOS_VTL L=50e-9 W='1*90e-9'
mn4217 col<185> sel<21> 0 0 NMOS_VTL L=50e-9 W='1*90e-9'
mn4218 col<186> sel<21> 0 0 NMOS_VTL L=50e-9 W='1*90e-9'
mn4219 col<187> sel<21> 0 0 NMOS_VTL L=50e-9 W='1*90e-9'
mn4220 col<188> sel<21> 0 0 NMOS_VTL L=50e-9 W='1*90e-9'
mn4225 col<1> sel<22> 0 0 NMOS_VTL L=50e-9 W='1*90e-9'
mn4226 col<2> sel<22> 0 0 NMOS_VTL L=50e-9 W='1*90e-9'
mn4227 col<3> sel<22> 0 0 NMOS_VTL L=50e-9 W='1*90e-9'
mn4228 col<4> sel<22> 0 0 NMOS_VTL L=50e-9 W='1*90e-9'
mn4229 col<5> sel<22> 0 0 NMOS_VTL L=50e-9 W='1*90e-9'
mn4230 col<6> sel<22> 0 0 NMOS_VTL L=50e-9 W='1*90e-9'
mn4231 col<7> sel<22> 0 0 NMOS_VTL L=50e-9 W='1*90e-9'
mn4232 col<8> sel<22> 0 0 NMOS_VTL L=50e-9 W='1*90e-9'
mn4239 col<15> sel<22> 0 0 NMOS_VTL L=50e-9 W='1*90e-9'
mn4243 col<19> sel<22> 0 0 NMOS_VTL L=50e-9 W='1*90e-9'
mn4244 col<20> sel<22> 0 0 NMOS_VTL L=50e-9 W='1*90e-9'
mn4248 col<24> sel<22> 0 0 NMOS_VTL L=50e-9 W='1*90e-9'
mn4249 col<25> sel<22> 0 0 NMOS_VTL L=50e-9 W='1*90e-9'
mn4250 col<26> sel<22> 0 0 NMOS_VTL L=50e-9 W='1*90e-9'
mn4252 col<28> sel<22> 0 0 NMOS_VTL L=50e-9 W='1*90e-9'
mn4253 col<29> sel<22> 0 0 NMOS_VTL L=50e-9 W='1*90e-9'
mn4255 col<31> sel<22> 0 0 NMOS_VTL L=50e-9 W='1*90e-9'
mn4256 col<32> sel<22> 0 0 NMOS_VTL L=50e-9 W='1*90e-9'
mn4258 col<34> sel<22> 0 0 NMOS_VTL L=50e-9 W='1*90e-9'
mn4263 col<39> sel<22> 0 0 NMOS_VTL L=50e-9 W='1*90e-9'
mn4266 col<42> sel<22> 0 0 NMOS_VTL L=50e-9 W='1*90e-9'
mn4267 col<43> sel<22> 0 0 NMOS_VTL L=50e-9 W='1*90e-9'
mn4268 col<44> sel<22> 0 0 NMOS_VTL L=50e-9 W='1*90e-9'
mn4269 col<45> sel<22> 0 0 NMOS_VTL L=50e-9 W='1*90e-9'
mn4270 col<46> sel<22> 0 0 NMOS_VTL L=50e-9 W='1*90e-9'
mn4271 col<47> sel<22> 0 0 NMOS_VTL L=50e-9 W='1*90e-9'
mn4275 col<51> sel<22> 0 0 NMOS_VTL L=50e-9 W='1*90e-9'
mn4277 col<53> sel<22> 0 0 NMOS_VTL L=50e-9 W='1*90e-9'
mn4278 col<54> sel<22> 0 0 NMOS_VTL L=50e-9 W='1*90e-9'
mn4284 col<60> sel<22> 0 0 NMOS_VTL L=50e-9 W='1*90e-9'
mn4286 col<62> sel<22> 0 0 NMOS_VTL L=50e-9 W='1*90e-9'
mn4288 col<64> sel<22> 0 0 NMOS_VTL L=50e-9 W='1*90e-9'
mn4416 col<0> sel<23> 0 0 NMOS_VTL L=50e-9 W='1*90e-9'
mn4420 col<4> sel<23> 0 0 NMOS_VTL L=50e-9 W='1*90e-9'
mn4421 col<5> sel<23> 0 0 NMOS_VTL L=50e-9 W='1*90e-9'
mn4422 col<6> sel<23> 0 0 NMOS_VTL L=50e-9 W='1*90e-9'
mn4423 col<7> sel<23> 0 0 NMOS_VTL L=50e-9 W='1*90e-9'
mn4424 col<8> sel<23> 0 0 NMOS_VTL L=50e-9 W='1*90e-9'
mn4426 col<10> sel<23> 0 0 NMOS_VTL L=50e-9 W='1*90e-9'
mn4432 col<16> sel<23> 0 0 NMOS_VTL L=50e-9 W='1*90e-9'
mn4433 col<17> sel<23> 0 0 NMOS_VTL L=50e-9 W='1*90e-9'
mn4435 col<19> sel<23> 0 0 NMOS_VTL L=50e-9 W='1*90e-9'
mn4436 col<20> sel<23> 0 0 NMOS_VTL L=50e-9 W='1*90e-9'
mn4438 col<22> sel<23> 0 0 NMOS_VTL L=50e-9 W='1*90e-9'
mn4443 col<27> sel<23> 0 0 NMOS_VTL L=50e-9 W='1*90e-9'
mn4444 col<28> sel<23> 0 0 NMOS_VTL L=50e-9 W='1*90e-9'
mn4445 col<29> sel<23> 0 0 NMOS_VTL L=50e-9 W='1*90e-9'
mn4447 col<31> sel<23> 0 0 NMOS_VTL L=50e-9 W='1*90e-9'
mn4448 col<32> sel<23> 0 0 NMOS_VTL L=50e-9 W='1*90e-9'
mn4450 col<34> sel<23> 0 0 NMOS_VTL L=50e-9 W='1*90e-9'
mn4451 col<35> sel<23> 0 0 NMOS_VTL L=50e-9 W='1*90e-9'
mn4452 col<36> sel<23> 0 0 NMOS_VTL L=50e-9 W='1*90e-9'
mn4453 col<37> sel<23> 0 0 NMOS_VTL L=50e-9 W='1*90e-9'
mn4454 col<38> sel<23> 0 0 NMOS_VTL L=50e-9 W='1*90e-9'
mn4455 col<39> sel<23> 0 0 NMOS_VTL L=50e-9 W='1*90e-9'
mn4456 col<40> sel<23> 0 0 NMOS_VTL L=50e-9 W='1*90e-9'
mn4457 col<41> sel<23> 0 0 NMOS_VTL L=50e-9 W='1*90e-9'
mn4458 col<42> sel<23> 0 0 NMOS_VTL L=50e-9 W='1*90e-9'
mn4459 col<43> sel<23> 0 0 NMOS_VTL L=50e-9 W='1*90e-9'
mn4460 col<44> sel<23> 0 0 NMOS_VTL L=50e-9 W='1*90e-9'
mn4464 col<48> sel<23> 0 0 NMOS_VTL L=50e-9 W='1*90e-9'
mn4465 col<49> sel<23> 0 0 NMOS_VTL L=50e-9 W='1*90e-9'
mn4466 col<50> sel<23> 0 0 NMOS_VTL L=50e-9 W='1*90e-9'
mn4468 col<52> sel<23> 0 0 NMOS_VTL L=50e-9 W='1*90e-9'
mn4470 col<54> sel<23> 0 0 NMOS_VTL L=50e-9 W='1*90e-9'
mn4471 col<55> sel<23> 0 0 NMOS_VTL L=50e-9 W='1*90e-9'
mn4472 col<56> sel<23> 0 0 NMOS_VTL L=50e-9 W='1*90e-9'
mn4473 col<57> sel<23> 0 0 NMOS_VTL L=50e-9 W='1*90e-9'
mn4474 col<58> sel<23> 0 0 NMOS_VTL L=50e-9 W='1*90e-9'
mn4475 col<59> sel<23> 0 0 NMOS_VTL L=50e-9 W='1*90e-9'
mn4476 col<60> sel<23> 0 0 NMOS_VTL L=50e-9 W='1*90e-9'
mn4480 col<64> sel<23> 0 0 NMOS_VTL L=50e-9 W='1*90e-9'
mn4481 col<65> sel<23> 0 0 NMOS_VTL L=50e-9 W='1*90e-9'
mn4612 col<4> sel<24> 0 0 NMOS_VTL L=50e-9 W='1*90e-9'
mn4613 col<5> sel<24> 0 0 NMOS_VTL L=50e-9 W='1*90e-9'
mn4615 col<7> sel<24> 0 0 NMOS_VTL L=50e-9 W='1*90e-9'
mn4616 col<8> sel<24> 0 0 NMOS_VTL L=50e-9 W='1*90e-9'
mn4617 col<9> sel<24> 0 0 NMOS_VTL L=50e-9 W='1*90e-9'
mn4618 col<10> sel<24> 0 0 NMOS_VTL L=50e-9 W='1*90e-9'
mn4619 col<11> sel<24> 0 0 NMOS_VTL L=50e-9 W='1*90e-9'
mn4624 col<16> sel<24> 0 0 NMOS_VTL L=50e-9 W='1*90e-9'
mn4627 col<19> sel<24> 0 0 NMOS_VTL L=50e-9 W='1*90e-9'
mn4630 col<22> sel<24> 0 0 NMOS_VTL L=50e-9 W='1*90e-9'
mn4631 col<23> sel<24> 0 0 NMOS_VTL L=50e-9 W='1*90e-9'
mn4632 col<24> sel<24> 0 0 NMOS_VTL L=50e-9 W='1*90e-9'
mn4636 col<28> sel<24> 0 0 NMOS_VTL L=50e-9 W='1*90e-9'
mn4637 col<29> sel<24> 0 0 NMOS_VTL L=50e-9 W='1*90e-9'
mn4638 col<30> sel<24> 0 0 NMOS_VTL L=50e-9 W='1*90e-9'
mn4639 col<31> sel<24> 0 0 NMOS_VTL L=50e-9 W='1*90e-9'
mn4640 col<32> sel<24> 0 0 NMOS_VTL L=50e-9 W='1*90e-9'
mn4641 col<33> sel<24> 0 0 NMOS_VTL L=50e-9 W='1*90e-9'
mn4642 col<34> sel<24> 0 0 NMOS_VTL L=50e-9 W='1*90e-9'
mn4643 col<35> sel<24> 0 0 NMOS_VTL L=50e-9 W='1*90e-9'
mn4644 col<36> sel<24> 0 0 NMOS_VTL L=50e-9 W='1*90e-9'
mn4647 col<39> sel<24> 0 0 NMOS_VTL L=50e-9 W='1*90e-9'
mn4648 col<40> sel<24> 0 0 NMOS_VTL L=50e-9 W='1*90e-9'
mn4649 col<41> sel<24> 0 0 NMOS_VTL L=50e-9 W='1*90e-9'
mn4653 col<45> sel<24> 0 0 NMOS_VTL L=50e-9 W='1*90e-9'
mn4654 col<46> sel<24> 0 0 NMOS_VTL L=50e-9 W='1*90e-9'
mn4655 col<47> sel<24> 0 0 NMOS_VTL L=50e-9 W='1*90e-9'
mn4656 col<48> sel<24> 0 0 NMOS_VTL L=50e-9 W='1*90e-9'
mn4666 col<58> sel<24> 0 0 NMOS_VTL L=50e-9 W='1*90e-9'
mn4669 col<61> sel<24> 0 0 NMOS_VTL L=50e-9 W='1*90e-9'
mn4670 col<62> sel<24> 0 0 NMOS_VTL L=50e-9 W='1*90e-9'
mn4672 col<64> sel<24> 0 0 NMOS_VTL L=50e-9 W='1*90e-9'
mn4673 col<65> sel<24> 0 0 NMOS_VTL L=50e-9 W='1*90e-9'
mn4800 col<0> sel<25> 0 0 NMOS_VTL L=50e-9 W='1*90e-9'
mn4801 col<1> sel<25> 0 0 NMOS_VTL L=50e-9 W='1*90e-9'
mn4802 col<2> sel<25> 0 0 NMOS_VTL L=50e-9 W='1*90e-9'
mn4803 col<3> sel<25> 0 0 NMOS_VTL L=50e-9 W='1*90e-9'
mn4805 col<5> sel<25> 0 0 NMOS_VTL L=50e-9 W='1*90e-9'
mn4806 col<6> sel<25> 0 0 NMOS_VTL L=50e-9 W='1*90e-9'
mn4816 col<16> sel<25> 0 0 NMOS_VTL L=50e-9 W='1*90e-9'
mn4817 col<17> sel<25> 0 0 NMOS_VTL L=50e-9 W='1*90e-9'
mn4818 col<18> sel<25> 0 0 NMOS_VTL L=50e-9 W='1*90e-9'
mn4819 col<19> sel<25> 0 0 NMOS_VTL L=50e-9 W='1*90e-9'
mn4820 col<20> sel<25> 0 0 NMOS_VTL L=50e-9 W='1*90e-9'
mn4822 col<22> sel<25> 0 0 NMOS_VTL L=50e-9 W='1*90e-9'
mn4823 col<23> sel<25> 0 0 NMOS_VTL L=50e-9 W='1*90e-9'
mn4825 col<25> sel<25> 0 0 NMOS_VTL L=50e-9 W='1*90e-9'
mn4826 col<26> sel<25> 0 0 NMOS_VTL L=50e-9 W='1*90e-9'
mn4827 col<27> sel<25> 0 0 NMOS_VTL L=50e-9 W='1*90e-9'
mn4830 col<30> sel<25> 0 0 NMOS_VTL L=50e-9 W='1*90e-9'
mn4831 col<31> sel<25> 0 0 NMOS_VTL L=50e-9 W='1*90e-9'
mn4832 col<32> sel<25> 0 0 NMOS_VTL L=50e-9 W='1*90e-9'
mn4833 col<33> sel<25> 0 0 NMOS_VTL L=50e-9 W='1*90e-9'
mn4852 col<52> sel<25> 0 0 NMOS_VTL L=50e-9 W='1*90e-9'
mn4857 col<57> sel<25> 0 0 NMOS_VTL L=50e-9 W='1*90e-9'
mn4863 col<63> sel<25> 0 0 NMOS_VTL L=50e-9 W='1*90e-9'
mn4864 col<64> sel<25> 0 0 NMOS_VTL L=50e-9 W='1*90e-9'
mn4865 col<65> sel<25> 0 0 NMOS_VTL L=50e-9 W='1*90e-9'
mn4992 col<0> sel<26> 0 0 NMOS_VTL L=50e-9 W='1*90e-9'
mn4993 col<1> sel<26> 0 0 NMOS_VTL L=50e-9 W='1*90e-9'
mn4994 col<2> sel<26> 0 0 NMOS_VTL L=50e-9 W='1*90e-9'
mn4995 col<3> sel<26> 0 0 NMOS_VTL L=50e-9 W='1*90e-9'
mn4998 col<6> sel<26> 0 0 NMOS_VTL L=50e-9 W='1*90e-9'
mn5001 col<9> sel<26> 0 0 NMOS_VTL L=50e-9 W='1*90e-9'
mn5002 col<10> sel<26> 0 0 NMOS_VTL L=50e-9 W='1*90e-9'
mn5003 col<11> sel<26> 0 0 NMOS_VTL L=50e-9 W='1*90e-9'
mn5008 col<16> sel<26> 0 0 NMOS_VTL L=50e-9 W='1*90e-9'
mn5009 col<17> sel<26> 0 0 NMOS_VTL L=50e-9 W='1*90e-9'
mn5011 col<19> sel<26> 0 0 NMOS_VTL L=50e-9 W='1*90e-9'
mn5013 col<21> sel<26> 0 0 NMOS_VTL L=50e-9 W='1*90e-9'
mn5014 col<22> sel<26> 0 0 NMOS_VTL L=50e-9 W='1*90e-9'
mn5015 col<23> sel<26> 0 0 NMOS_VTL L=50e-9 W='1*90e-9'
mn5017 col<25> sel<26> 0 0 NMOS_VTL L=50e-9 W='1*90e-9'
mn5018 col<26> sel<26> 0 0 NMOS_VTL L=50e-9 W='1*90e-9'
mn5020 col<28> sel<26> 0 0 NMOS_VTL L=50e-9 W='1*90e-9'
mn5021 col<29> sel<26> 0 0 NMOS_VTL L=50e-9 W='1*90e-9'
mn5022 col<30> sel<26> 0 0 NMOS_VTL L=50e-9 W='1*90e-9'
mn5025 col<33> sel<26> 0 0 NMOS_VTL L=50e-9 W='1*90e-9'
mn5027 col<35> sel<26> 0 0 NMOS_VTL L=50e-9 W='1*90e-9'
mn5028 col<36> sel<26> 0 0 NMOS_VTL L=50e-9 W='1*90e-9'
mn5029 col<37> sel<26> 0 0 NMOS_VTL L=50e-9 W='1*90e-9'
mn5030 col<38> sel<26> 0 0 NMOS_VTL L=50e-9 W='1*90e-9'
mn5031 col<39> sel<26> 0 0 NMOS_VTL L=50e-9 W='1*90e-9'
mn5032 col<40> sel<26> 0 0 NMOS_VTL L=50e-9 W='1*90e-9'
mn5033 col<41> sel<26> 0 0 NMOS_VTL L=50e-9 W='1*90e-9'
mn5037 col<45> sel<26> 0 0 NMOS_VTL L=50e-9 W='1*90e-9'
mn5038 col<46> sel<26> 0 0 NMOS_VTL L=50e-9 W='1*90e-9'
mn5039 col<47> sel<26> 0 0 NMOS_VTL L=50e-9 W='1*90e-9'
mn5044 col<52> sel<26> 0 0 NMOS_VTL L=50e-9 W='1*90e-9'
mn5045 col<53> sel<26> 0 0 NMOS_VTL L=50e-9 W='1*90e-9'
mn5047 col<55> sel<26> 0 0 NMOS_VTL L=50e-9 W='1*90e-9'
mn5048 col<56> sel<26> 0 0 NMOS_VTL L=50e-9 W='1*90e-9'
mn5049 col<57> sel<26> 0 0 NMOS_VTL L=50e-9 W='1*90e-9'
mn5050 col<58> sel<26> 0 0 NMOS_VTL L=50e-9 W='1*90e-9'
mn5051 col<59> sel<26> 0 0 NMOS_VTL L=50e-9 W='1*90e-9'
mn5053 col<61> sel<26> 0 0 NMOS_VTL L=50e-9 W='1*90e-9'
mn5055 col<63> sel<26> 0 0 NMOS_VTL L=50e-9 W='1*90e-9'
mn5187 col<3> sel<27> 0 0 NMOS_VTL L=50e-9 W='1*90e-9'
mn5188 col<4> sel<27> 0 0 NMOS_VTL L=50e-9 W='1*90e-9'
mn5189 col<5> sel<27> 0 0 NMOS_VTL L=50e-9 W='1*90e-9'
mn5190 col<6> sel<27> 0 0 NMOS_VTL L=50e-9 W='1*90e-9'
mn5199 col<15> sel<27> 0 0 NMOS_VTL L=50e-9 W='1*90e-9'
mn5202 col<18> sel<27> 0 0 NMOS_VTL L=50e-9 W='1*90e-9'
mn5203 col<19> sel<27> 0 0 NMOS_VTL L=50e-9 W='1*90e-9'
mn5204 col<20> sel<27> 0 0 NMOS_VTL L=50e-9 W='1*90e-9'
mn5209 col<25> sel<27> 0 0 NMOS_VTL L=50e-9 W='1*90e-9'
mn5210 col<26> sel<27> 0 0 NMOS_VTL L=50e-9 W='1*90e-9'
mn5217 col<33> sel<27> 0 0 NMOS_VTL L=50e-9 W='1*90e-9'
mn5220 col<36> sel<27> 0 0 NMOS_VTL L=50e-9 W='1*90e-9'
mn5221 col<37> sel<27> 0 0 NMOS_VTL L=50e-9 W='1*90e-9'
mn5222 col<38> sel<27> 0 0 NMOS_VTL L=50e-9 W='1*90e-9'
mn5224 col<40> sel<27> 0 0 NMOS_VTL L=50e-9 W='1*90e-9'
mn5233 col<49> sel<27> 0 0 NMOS_VTL L=50e-9 W='1*90e-9'
mn5234 col<50> sel<27> 0 0 NMOS_VTL L=50e-9 W='1*90e-9'
mn5235 col<51> sel<27> 0 0 NMOS_VTL L=50e-9 W='1*90e-9'
mn5236 col<52> sel<27> 0 0 NMOS_VTL L=50e-9 W='1*90e-9'
mn5237 col<53> sel<27> 0 0 NMOS_VTL L=50e-9 W='1*90e-9'
mn5238 col<54> sel<27> 0 0 NMOS_VTL L=50e-9 W='1*90e-9'
mn5239 col<55> sel<27> 0 0 NMOS_VTL L=50e-9 W='1*90e-9'
mn5240 col<56> sel<27> 0 0 NMOS_VTL L=50e-9 W='1*90e-9'
mn5242 col<58> sel<27> 0 0 NMOS_VTL L=50e-9 W='1*90e-9'
mn5243 col<59> sel<27> 0 0 NMOS_VTL L=50e-9 W='1*90e-9'
mn5247 col<63> sel<27> 0 0 NMOS_VTL L=50e-9 W='1*90e-9'
mn5248 col<64> sel<27> 0 0 NMOS_VTL L=50e-9 W='1*90e-9'
mn5249 col<65> sel<27> 0 0 NMOS_VTL L=50e-9 W='1*90e-9'
mn5377 col<1> sel<28> 0 0 NMOS_VTL L=50e-9 W='1*90e-9'
mn5378 col<2> sel<28> 0 0 NMOS_VTL L=50e-9 W='1*90e-9'
mn5379 col<3> sel<28> 0 0 NMOS_VTL L=50e-9 W='1*90e-9'
mn5380 col<4> sel<28> 0 0 NMOS_VTL L=50e-9 W='1*90e-9'
mn5381 col<5> sel<28> 0 0 NMOS_VTL L=50e-9 W='1*90e-9'
mn5392 col<16> sel<28> 0 0 NMOS_VTL L=50e-9 W='1*90e-9'
mn5394 col<18> sel<28> 0 0 NMOS_VTL L=50e-9 W='1*90e-9'
mn5395 col<19> sel<28> 0 0 NMOS_VTL L=50e-9 W='1*90e-9'
mn5396 col<20> sel<28> 0 0 NMOS_VTL L=50e-9 W='1*90e-9'
mn5403 col<27> sel<28> 0 0 NMOS_VTL L=50e-9 W='1*90e-9'
mn5404 col<28> sel<28> 0 0 NMOS_VTL L=50e-9 W='1*90e-9'
mn5405 col<29> sel<28> 0 0 NMOS_VTL L=50e-9 W='1*90e-9'
mn5406 col<30> sel<28> 0 0 NMOS_VTL L=50e-9 W='1*90e-9'
mn5409 col<33> sel<28> 0 0 NMOS_VTL L=50e-9 W='1*90e-9'
mn5411 col<35> sel<28> 0 0 NMOS_VTL L=50e-9 W='1*90e-9'
mn5412 col<36> sel<28> 0 0 NMOS_VTL L=50e-9 W='1*90e-9'
mn5415 col<39> sel<28> 0 0 NMOS_VTL L=50e-9 W='1*90e-9'
mn5416 col<40> sel<28> 0 0 NMOS_VTL L=50e-9 W='1*90e-9'
mn5417 col<41> sel<28> 0 0 NMOS_VTL L=50e-9 W='1*90e-9'
mn5418 col<42> sel<28> 0 0 NMOS_VTL L=50e-9 W='1*90e-9'
mn5419 col<43> sel<28> 0 0 NMOS_VTL L=50e-9 W='1*90e-9'
mn5420 col<44> sel<28> 0 0 NMOS_VTL L=50e-9 W='1*90e-9'
mn5421 col<45> sel<28> 0 0 NMOS_VTL L=50e-9 W='1*90e-9'
mn5422 col<46> sel<28> 0 0 NMOS_VTL L=50e-9 W='1*90e-9'
mn5423 col<47> sel<28> 0 0 NMOS_VTL L=50e-9 W='1*90e-9'
mn5424 col<48> sel<28> 0 0 NMOS_VTL L=50e-9 W='1*90e-9'
mn5425 col<49> sel<28> 0 0 NMOS_VTL L=50e-9 W='1*90e-9'
mn5426 col<50> sel<28> 0 0 NMOS_VTL L=50e-9 W='1*90e-9'
mn5428 col<52> sel<28> 0 0 NMOS_VTL L=50e-9 W='1*90e-9'
mn5429 col<53> sel<28> 0 0 NMOS_VTL L=50e-9 W='1*90e-9'
mn5431 col<55> sel<28> 0 0 NMOS_VTL L=50e-9 W='1*90e-9'
mn5432 col<56> sel<28> 0 0 NMOS_VTL L=50e-9 W='1*90e-9'
mn5433 col<57> sel<28> 0 0 NMOS_VTL L=50e-9 W='1*90e-9'
mn5437 col<61> sel<28> 0 0 NMOS_VTL L=50e-9 W='1*90e-9'
mn5438 col<62> sel<28> 0 0 NMOS_VTL L=50e-9 W='1*90e-9'
mn5439 col<63> sel<28> 0 0 NMOS_VTL L=50e-9 W='1*90e-9'
mn5568 col<0> sel<29> 0 0 NMOS_VTL L=50e-9 W='1*90e-9'
mn5571 col<3> sel<29> 0 0 NMOS_VTL L=50e-9 W='1*90e-9'
mn5572 col<4> sel<29> 0 0 NMOS_VTL L=50e-9 W='1*90e-9'
mn5577 col<9> sel<29> 0 0 NMOS_VTL L=50e-9 W='1*90e-9'
mn5578 col<10> sel<29> 0 0 NMOS_VTL L=50e-9 W='1*90e-9'
mn5579 col<11> sel<29> 0 0 NMOS_VTL L=50e-9 W='1*90e-9'
mn5580 col<12> sel<29> 0 0 NMOS_VTL L=50e-9 W='1*90e-9'
mn5581 col<13> sel<29> 0 0 NMOS_VTL L=50e-9 W='1*90e-9'
mn5582 col<14> sel<29> 0 0 NMOS_VTL L=50e-9 W='1*90e-9'
mn5583 col<15> sel<29> 0 0 NMOS_VTL L=50e-9 W='1*90e-9'
mn5585 col<17> sel<29> 0 0 NMOS_VTL L=50e-9 W='1*90e-9'
mn5586 col<18> sel<29> 0 0 NMOS_VTL L=50e-9 W='1*90e-9'
mn5587 col<19> sel<29> 0 0 NMOS_VTL L=50e-9 W='1*90e-9'
mn5588 col<20> sel<29> 0 0 NMOS_VTL L=50e-9 W='1*90e-9'
mn5592 col<24> sel<29> 0 0 NMOS_VTL L=50e-9 W='1*90e-9'
mn5598 col<30> sel<29> 0 0 NMOS_VTL L=50e-9 W='1*90e-9'
mn5599 col<31> sel<29> 0 0 NMOS_VTL L=50e-9 W='1*90e-9'
mn5600 col<32> sel<29> 0 0 NMOS_VTL L=50e-9 W='1*90e-9'
mn5602 col<34> sel<29> 0 0 NMOS_VTL L=50e-9 W='1*90e-9'
mn5605 col<37> sel<29> 0 0 NMOS_VTL L=50e-9 W='1*90e-9'
mn5606 col<38> sel<29> 0 0 NMOS_VTL L=50e-9 W='1*90e-9'
mn5613 col<45> sel<29> 0 0 NMOS_VTL L=50e-9 W='1*90e-9'
mn5614 col<46> sel<29> 0 0 NMOS_VTL L=50e-9 W='1*90e-9'
mn5615 col<47> sel<29> 0 0 NMOS_VTL L=50e-9 W='1*90e-9'
mn5616 col<48> sel<29> 0 0 NMOS_VTL L=50e-9 W='1*90e-9'
mn5623 col<55> sel<29> 0 0 NMOS_VTL L=50e-9 W='1*90e-9'
mn5624 col<56> sel<29> 0 0 NMOS_VTL L=50e-9 W='1*90e-9'
mn5625 col<57> sel<29> 0 0 NMOS_VTL L=50e-9 W='1*90e-9'
mn5626 col<58> sel<29> 0 0 NMOS_VTL L=50e-9 W='1*90e-9'
mn5627 col<59> sel<29> 0 0 NMOS_VTL L=50e-9 W='1*90e-9'
mn5629 col<61> sel<29> 0 0 NMOS_VTL L=50e-9 W='1*90e-9'
mn5630 col<62> sel<29> 0 0 NMOS_VTL L=50e-9 W='1*90e-9'
mn5632 col<64> sel<29> 0 0 NMOS_VTL L=50e-9 W='1*90e-9'
mn5633 col<65> sel<29> 0 0 NMOS_VTL L=50e-9 W='1*90e-9'
mn5763 col<3> sel<30> 0 0 NMOS_VTL L=50e-9 W='1*90e-9'
mn5767 col<7> sel<30> 0 0 NMOS_VTL L=50e-9 W='1*90e-9'
mn5768 col<8> sel<30> 0 0 NMOS_VTL L=50e-9 W='1*90e-9'
mn5770 col<10> sel<30> 0 0 NMOS_VTL L=50e-9 W='1*90e-9'
mn5771 col<11> sel<30> 0 0 NMOS_VTL L=50e-9 W='1*90e-9'
mn5775 col<15> sel<30> 0 0 NMOS_VTL L=50e-9 W='1*90e-9'
mn5779 col<19> sel<30> 0 0 NMOS_VTL L=50e-9 W='1*90e-9'
mn5780 col<20> sel<30> 0 0 NMOS_VTL L=50e-9 W='1*90e-9'
mn5784 col<24> sel<30> 0 0 NMOS_VTL L=50e-9 W='1*90e-9'
mn5785 col<25> sel<30> 0 0 NMOS_VTL L=50e-9 W='1*90e-9'
mn5786 col<26> sel<30> 0 0 NMOS_VTL L=50e-9 W='1*90e-9'
mn5791 col<31> sel<30> 0 0 NMOS_VTL L=50e-9 W='1*90e-9'
mn5792 col<32> sel<30> 0 0 NMOS_VTL L=50e-9 W='1*90e-9'
mn5796 col<36> sel<30> 0 0 NMOS_VTL L=50e-9 W='1*90e-9'
mn5799 col<39> sel<30> 0 0 NMOS_VTL L=50e-9 W='1*90e-9'
mn5800 col<40> sel<30> 0 0 NMOS_VTL L=50e-9 W='1*90e-9'
mn5801 col<41> sel<30> 0 0 NMOS_VTL L=50e-9 W='1*90e-9'
mn5809 col<49> sel<30> 0 0 NMOS_VTL L=50e-9 W='1*90e-9'
mn5810 col<50> sel<30> 0 0 NMOS_VTL L=50e-9 W='1*90e-9'
mn5811 col<51> sel<30> 0 0 NMOS_VTL L=50e-9 W='1*90e-9'
mn5812 col<52> sel<30> 0 0 NMOS_VTL L=50e-9 W='1*90e-9'
mn5813 col<53> sel<30> 0 0 NMOS_VTL L=50e-9 W='1*90e-9'
mn5814 col<54> sel<30> 0 0 NMOS_VTL L=50e-9 W='1*90e-9'
mn5815 col<55> sel<30> 0 0 NMOS_VTL L=50e-9 W='1*90e-9'
mn5816 col<56> sel<30> 0 0 NMOS_VTL L=50e-9 W='1*90e-9'
mn5821 col<61> sel<30> 0 0 NMOS_VTL L=50e-9 W='1*90e-9'
mn5824 col<64> sel<30> 0 0 NMOS_VTL L=50e-9 W='1*90e-9'
mn5825 col<65> sel<30> 0 0 NMOS_VTL L=50e-9 W='1*90e-9'
mn5952 col<0> sel<31> 0 0 NMOS_VTL L=50e-9 W='1*90e-9'
mn5953 col<1> sel<31> 0 0 NMOS_VTL L=50e-9 W='1*90e-9'
mn5954 col<2> sel<31> 0 0 NMOS_VTL L=50e-9 W='1*90e-9'
mn5956 col<4> sel<31> 0 0 NMOS_VTL L=50e-9 W='1*90e-9'
mn5958 col<6> sel<31> 0 0 NMOS_VTL L=50e-9 W='1*90e-9'
mn5959 col<7> sel<31> 0 0 NMOS_VTL L=50e-9 W='1*90e-9'
mn5960 col<8> sel<31> 0 0 NMOS_VTL L=50e-9 W='1*90e-9'
mn5961 col<9> sel<31> 0 0 NMOS_VTL L=50e-9 W='1*90e-9'
mn5962 col<10> sel<31> 0 0 NMOS_VTL L=50e-9 W='1*90e-9'
mn5963 col<11> sel<31> 0 0 NMOS_VTL L=50e-9 W='1*90e-9'
mn5964 col<12> sel<31> 0 0 NMOS_VTL L=50e-9 W='1*90e-9'
mn5965 col<13> sel<31> 0 0 NMOS_VTL L=50e-9 W='1*90e-9'
mn5966 col<14> sel<31> 0 0 NMOS_VTL L=50e-9 W='1*90e-9'
mn5967 col<15> sel<31> 0 0 NMOS_VTL L=50e-9 W='1*90e-9'
mn5968 col<16> sel<31> 0 0 NMOS_VTL L=50e-9 W='1*90e-9'
mn5969 col<17> sel<31> 0 0 NMOS_VTL L=50e-9 W='1*90e-9'
mn5970 col<18> sel<31> 0 0 NMOS_VTL L=50e-9 W='1*90e-9'
mn5973 col<21> sel<31> 0 0 NMOS_VTL L=50e-9 W='1*90e-9'
mn5974 col<22> sel<31> 0 0 NMOS_VTL L=50e-9 W='1*90e-9'
mn5975 col<23> sel<31> 0 0 NMOS_VTL L=50e-9 W='1*90e-9'
mn5988 col<36> sel<31> 0 0 NMOS_VTL L=50e-9 W='1*90e-9'
mn5990 col<38> sel<31> 0 0 NMOS_VTL L=50e-9 W='1*90e-9'
mn5992 col<40> sel<31> 0 0 NMOS_VTL L=50e-9 W='1*90e-9'
mn5993 col<41> sel<31> 0 0 NMOS_VTL L=50e-9 W='1*90e-9'
mn5994 col<42> sel<31> 0 0 NMOS_VTL L=50e-9 W='1*90e-9'
mn5995 col<43> sel<31> 0 0 NMOS_VTL L=50e-9 W='1*90e-9'
mn5996 col<44> sel<31> 0 0 NMOS_VTL L=50e-9 W='1*90e-9'
mn5997 col<45> sel<31> 0 0 NMOS_VTL L=50e-9 W='1*90e-9'
mn5998 col<46> sel<31> 0 0 NMOS_VTL L=50e-9 W='1*90e-9'
mn5999 col<47> sel<31> 0 0 NMOS_VTL L=50e-9 W='1*90e-9'
mn6006 col<54> sel<31> 0 0 NMOS_VTL L=50e-9 W='1*90e-9'
mn6007 col<55> sel<31> 0 0 NMOS_VTL L=50e-9 W='1*90e-9'
mn6008 col<56> sel<31> 0 0 NMOS_VTL L=50e-9 W='1*90e-9'
mn6010 col<58> sel<31> 0 0 NMOS_VTL L=50e-9 W='1*90e-9'
mn6011 col<59> sel<31> 0 0 NMOS_VTL L=50e-9 W='1*90e-9'
xrom_inv0 col<0> out<0> xrom_weight_inv s=1
xrom_inv1 col<1> out<1> xrom_weight_inv s=1
xrom_inv2 col<2> out<2> xrom_weight_inv s=1
xrom_inv3 col<3> out<3> xrom_weight_inv s=1
xrom_inv4 col<4> out<4> xrom_weight_inv s=1
xrom_inv5 col<5> out<5> xrom_weight_inv s=1
xrom_inv6 col<6> out<6> xrom_weight_inv s=1
xrom_inv7 col<7> out<7> xrom_weight_inv s=1
xrom_inv8 col<8> out<8> xrom_weight_inv s=1
xrom_inv9 col<9> out<9> xrom_weight_inv s=1
xrom_inv10 col<10> out<10> xrom_weight_inv s=1
xrom_inv11 col<11> out<11> xrom_weight_inv s=1
xrom_inv12 col<12> out<12> xrom_weight_inv s=1
xrom_inv13 col<13> out<13> xrom_weight_inv s=1
xrom_inv14 col<14> out<14> xrom_weight_inv s=1
xrom_inv15 col<15> out<15> xrom_weight_inv s=1
xrom_inv16 col<16> out<16> xrom_weight_inv s=1
xrom_inv17 col<17> out<17> xrom_weight_inv s=1
xrom_inv18 col<18> out<18> xrom_weight_inv s=1
xrom_inv19 col<19> out<19> xrom_weight_inv s=1
xrom_inv20 col<20> out<20> xrom_weight_inv s=1
xrom_inv21 col<21> out<21> xrom_weight_inv s=1
xrom_inv22 col<22> out<22> xrom_weight_inv s=1
xrom_inv23 col<23> out<23> xrom_weight_inv s=1
xrom_inv24 col<24> out<24> xrom_weight_inv s=1
xrom_inv25 col<25> out<25> xrom_weight_inv s=1
xrom_inv26 col<26> out<26> xrom_weight_inv s=1
xrom_inv27 col<27> out<27> xrom_weight_inv s=1
xrom_inv28 col<28> out<28> xrom_weight_inv s=1
xrom_inv29 col<29> out<29> xrom_weight_inv s=1
xrom_inv30 col<30> out<30> xrom_weight_inv s=1
xrom_inv31 col<31> out<31> xrom_weight_inv s=1
xrom_inv32 col<32> out<32> xrom_weight_inv s=1
xrom_inv33 col<33> out<33> xrom_weight_inv s=1
xrom_inv34 col<34> out<34> xrom_weight_inv s=1
xrom_inv35 col<35> out<35> xrom_weight_inv s=1
xrom_inv36 col<36> out<36> xrom_weight_inv s=1
xrom_inv37 col<37> out<37> xrom_weight_inv s=1
xrom_inv38 col<38> out<38> xrom_weight_inv s=1
xrom_inv39 col<39> out<39> xrom_weight_inv s=1
xrom_inv40 col<40> out<40> xrom_weight_inv s=1
xrom_inv41 col<41> out<41> xrom_weight_inv s=1
xrom_inv42 col<42> out<42> xrom_weight_inv s=1
xrom_inv43 col<43> out<43> xrom_weight_inv s=1
xrom_inv44 col<44> out<44> xrom_weight_inv s=1
xrom_inv45 col<45> out<45> xrom_weight_inv s=1
xrom_inv46 col<46> out<46> xrom_weight_inv s=1
xrom_inv47 col<47> out<47> xrom_weight_inv s=1
xrom_inv48 col<48> out<48> xrom_weight_inv s=1
xrom_inv49 col<49> out<49> xrom_weight_inv s=1
xrom_inv50 col<50> out<50> xrom_weight_inv s=1
xrom_inv51 col<51> out<51> xrom_weight_inv s=1
xrom_inv52 col<52> out<52> xrom_weight_inv s=1
xrom_inv53 col<53> out<53> xrom_weight_inv s=1
xrom_inv54 col<54> out<54> xrom_weight_inv s=1
xrom_inv55 col<55> out<55> xrom_weight_inv s=1
xrom_inv56 col<56> out<56> xrom_weight_inv s=1
xrom_inv57 col<57> out<57> xrom_weight_inv s=1
xrom_inv58 col<58> out<58> xrom_weight_inv s=1
xrom_inv59 col<59> out<59> xrom_weight_inv s=1
xrom_inv60 col<60> out<60> xrom_weight_inv s=1
xrom_inv61 col<61> out<61> xrom_weight_inv s=1
xrom_inv62 col<62> out<62> xrom_weight_inv s=1
xrom_inv63 col<63> out<63> xrom_weight_inv s=1
xrom_inv64 col<64> out<64> xrom_weight_inv s=1
xrom_inv65 col<65> out<65> xrom_weight_inv s=1
xrom_inv66 col<66> out<66> xrom_weight_inv s=1
xrom_inv67 col<67> out<67> xrom_weight_inv s=1
xrom_inv68 col<68> out<68> xrom_weight_inv s=1
xrom_inv69 col<69> out<69> xrom_weight_inv s=1
xrom_inv70 col<70> out<70> xrom_weight_inv s=1
xrom_inv71 col<71> out<71> xrom_weight_inv s=1
xrom_inv72 col<72> out<72> xrom_weight_inv s=1
xrom_inv73 col<73> out<73> xrom_weight_inv s=1
xrom_inv74 col<74> out<74> xrom_weight_inv s=1
xrom_inv75 col<75> out<75> xrom_weight_inv s=1
xrom_inv76 col<76> out<76> xrom_weight_inv s=1
xrom_inv77 col<77> out<77> xrom_weight_inv s=1
xrom_inv78 col<78> out<78> xrom_weight_inv s=1
xrom_inv79 col<79> out<79> xrom_weight_inv s=1
xrom_inv80 col<80> out<80> xrom_weight_inv s=1
xrom_inv81 col<81> out<81> xrom_weight_inv s=1
xrom_inv82 col<82> out<82> xrom_weight_inv s=1
xrom_inv83 col<83> out<83> xrom_weight_inv s=1
xrom_inv84 col<84> out<84> xrom_weight_inv s=1
xrom_inv85 col<85> out<85> xrom_weight_inv s=1
xrom_inv86 col<86> out<86> xrom_weight_inv s=1
xrom_inv87 col<87> out<87> xrom_weight_inv s=1
xrom_inv88 col<88> out<88> xrom_weight_inv s=1
xrom_inv89 col<89> out<89> xrom_weight_inv s=1
xrom_inv90 col<90> out<90> xrom_weight_inv s=1
xrom_inv91 col<91> out<91> xrom_weight_inv s=1
xrom_inv92 col<92> out<92> xrom_weight_inv s=1
xrom_inv93 col<93> out<93> xrom_weight_inv s=1
xrom_inv94 col<94> out<94> xrom_weight_inv s=1
xrom_inv95 col<95> out<95> xrom_weight_inv s=1
xrom_inv96 col<96> out<96> xrom_weight_inv s=1
xrom_inv97 col<97> out<97> xrom_weight_inv s=1
xrom_inv98 col<98> out<98> xrom_weight_inv s=1
xrom_inv99 col<99> out<99> xrom_weight_inv s=1
xrom_inv100 col<100> out<100> xrom_weight_inv s=1
xrom_inv101 col<101> out<101> xrom_weight_inv s=1
xrom_inv102 col<102> out<102> xrom_weight_inv s=1
xrom_inv103 col<103> out<103> xrom_weight_inv s=1
xrom_inv104 col<104> out<104> xrom_weight_inv s=1
xrom_inv105 col<105> out<105> xrom_weight_inv s=1
xrom_inv106 col<106> out<106> xrom_weight_inv s=1
xrom_inv107 col<107> out<107> xrom_weight_inv s=1
xrom_inv108 col<108> out<108> xrom_weight_inv s=1
xrom_inv109 col<109> out<109> xrom_weight_inv s=1
xrom_inv110 col<110> out<110> xrom_weight_inv s=1
xrom_inv111 col<111> out<111> xrom_weight_inv s=1
xrom_inv112 col<112> out<112> xrom_weight_inv s=1
xrom_inv113 col<113> out<113> xrom_weight_inv s=1
xrom_inv114 col<114> out<114> xrom_weight_inv s=1
xrom_inv115 col<115> out<115> xrom_weight_inv s=1
xrom_inv116 col<116> out<116> xrom_weight_inv s=1
xrom_inv117 col<117> out<117> xrom_weight_inv s=1
xrom_inv118 col<118> out<118> xrom_weight_inv s=1
xrom_inv119 col<119> out<119> xrom_weight_inv s=1
xrom_inv120 col<120> out<120> xrom_weight_inv s=1
xrom_inv121 col<121> out<121> xrom_weight_inv s=1
xrom_inv122 col<122> out<122> xrom_weight_inv s=1
xrom_inv123 col<123> out<123> xrom_weight_inv s=1
xrom_inv124 col<124> out<124> xrom_weight_inv s=1
xrom_inv125 col<125> out<125> xrom_weight_inv s=1
xrom_inv126 col<126> out<126> xrom_weight_inv s=1
xrom_inv127 col<127> out<127> xrom_weight_inv s=1
xrom_inv128 col<128> out<128> xrom_weight_inv s=1
xrom_inv129 col<129> out<129> xrom_weight_inv s=1
xrom_inv130 col<130> out<130> xrom_weight_inv s=1
xrom_inv131 col<131> out<131> xrom_weight_inv s=1
xrom_inv132 col<132> out<132> xrom_weight_inv s=1
xrom_inv133 col<133> out<133> xrom_weight_inv s=1
xrom_inv134 col<134> out<134> xrom_weight_inv s=1
xrom_inv135 col<135> out<135> xrom_weight_inv s=1
xrom_inv136 col<136> out<136> xrom_weight_inv s=1
xrom_inv137 col<137> out<137> xrom_weight_inv s=1
xrom_inv138 col<138> out<138> xrom_weight_inv s=1
xrom_inv139 col<139> out<139> xrom_weight_inv s=1
xrom_inv140 col<140> out<140> xrom_weight_inv s=1
xrom_inv141 col<141> out<141> xrom_weight_inv s=1
xrom_inv142 col<142> out<142> xrom_weight_inv s=1
xrom_inv143 col<143> out<143> xrom_weight_inv s=1
xrom_inv144 col<144> out<144> xrom_weight_inv s=1
xrom_inv145 col<145> out<145> xrom_weight_inv s=1
xrom_inv146 col<146> out<146> xrom_weight_inv s=1
xrom_inv147 col<147> out<147> xrom_weight_inv s=1
xrom_inv148 col<148> out<148> xrom_weight_inv s=1
xrom_inv149 col<149> out<149> xrom_weight_inv s=1
xrom_inv150 col<150> out<150> xrom_weight_inv s=1
xrom_inv151 col<151> out<151> xrom_weight_inv s=1
xrom_inv152 col<152> out<152> xrom_weight_inv s=1
xrom_inv153 col<153> out<153> xrom_weight_inv s=1
xrom_inv154 col<154> out<154> xrom_weight_inv s=1
xrom_inv155 col<155> out<155> xrom_weight_inv s=1
xrom_inv156 col<156> out<156> xrom_weight_inv s=1
xrom_inv157 col<157> out<157> xrom_weight_inv s=1
xrom_inv158 col<158> out<158> xrom_weight_inv s=1
xrom_inv159 col<159> out<159> xrom_weight_inv s=1
xrom_inv160 col<160> out<160> xrom_weight_inv s=1
xrom_inv161 col<161> out<161> xrom_weight_inv s=1
xrom_inv162 col<162> out<162> xrom_weight_inv s=1
xrom_inv163 col<163> out<163> xrom_weight_inv s=1
xrom_inv164 col<164> out<164> xrom_weight_inv s=1
xrom_inv165 col<165> out<165> xrom_weight_inv s=1
xrom_inv166 col<166> out<166> xrom_weight_inv s=1
xrom_inv167 col<167> out<167> xrom_weight_inv s=1
xrom_inv168 col<168> out<168> xrom_weight_inv s=1
xrom_inv169 col<169> out<169> xrom_weight_inv s=1
xrom_inv170 col<170> out<170> xrom_weight_inv s=1
xrom_inv171 col<171> out<171> xrom_weight_inv s=1
xrom_inv172 col<172> out<172> xrom_weight_inv s=1
xrom_inv173 col<173> out<173> xrom_weight_inv s=1
xrom_inv174 col<174> out<174> xrom_weight_inv s=1
xrom_inv175 col<175> out<175> xrom_weight_inv s=1
xrom_inv176 col<176> out<176> xrom_weight_inv s=1
xrom_inv177 col<177> out<177> xrom_weight_inv s=1
xrom_inv178 col<178> out<178> xrom_weight_inv s=1
xrom_inv179 col<179> out<179> xrom_weight_inv s=1
xrom_inv180 col<180> out<180> xrom_weight_inv s=1
xrom_inv181 col<181> out<181> xrom_weight_inv s=1
xrom_inv182 col<182> out<182> xrom_weight_inv s=1
xrom_inv183 col<183> out<183> xrom_weight_inv s=1
xrom_inv184 col<184> out<184> xrom_weight_inv s=1
xrom_inv185 col<185> out<185> xrom_weight_inv s=1
xrom_inv186 col<186> out<186> xrom_weight_inv s=1
xrom_inv187 col<187> out<187> xrom_weight_inv s=1
xrom_inv188 col<188> out<188> xrom_weight_inv s=1
xrom_inv189 col<189> out<189> xrom_weight_inv s=1
xrom_inv190 col<190> out<190> xrom_weight_inv s=1
xrom_inv191 col<191> out<191> xrom_weight_inv s=1
.ends

.subckt xrom_weight addr<0> addr<1> addr<2> addr<3> addr<4> weight<0> weight<1> weight<2> weight<3> weight<4> weight<5> weight<6> weight<7> weight<8> weight<9> weight<10>
+ weight<11> weight<12> weight<13> weight<14> weight<15> weight<16> weight<17> weight<18> weight<19> weight<20> weight<21> weight<22> weight<23> weight<24> weight<25> weight<26>
+ weight<27> weight<28> weight<29> weight<30> weight<31> weight<32> weight<33> weight<34> weight<35> weight<36> weight<37> weight<38> weight<39> weight<40> weight<41> weight<42>
+ weight<43> weight<44> weight<45> weight<46> weight<47> weight<48> weight<49> weight<50> weight<51> weight<52> weight<53> weight<54> weight<55> weight<56> weight<57> weight<58>
+ weight<59> weight<60> weight<61> weight<62> weight<63> weight<64> weight<65> weight<66> weight<67> weight<68> weight<69> weight<70> weight<71> weight<72> weight<73> weight<74>
+ weight<75> weight<76> weight<77> weight<78> weight<79> weight<80> weight<81> weight<82> weight<83> weight<84> weight<85> weight<86> weight<87> weight<88> weight<89> weight<90>
+ weight<91> weight<92> weight<93> weight<94> weight<95> weight<96> weight<97> weight<98> weight<99> weight<100> weight<101> weight<102> weight<103> weight<104> weight<105> weight<106>
+ weight<107> weight<108> weight<109> weight<110> weight<111> weight<112> weight<113> weight<114> weight<115> weight<116> weight<117> weight<118> weight<119> weight<120> weight<121> weight<122>
+ weight<123> weight<124> weight<125> weight<126> weight<127> weight<128> weight<129> weight<130> weight<131> weight<132> weight<133> weight<134> weight<135> weight<136> weight<137> weight<138>
+ weight<139> weight<140> weight<141> weight<142> weight<143> weight<144> weight<145> weight<146> weight<147> weight<148> weight<149> weight<150> weight<151> weight<152> weight<153> weight<154>
+ weight<155> weight<156> weight<157> weight<158> weight<159> weight<160> weight<161> weight<162> weight<163> weight<164> weight<165> weight<166> weight<167> weight<168> weight<169> weight<170>
+ weight<171> weight<172> weight<173> weight<174> weight<175> weight<176> weight<177> weight<178> weight<179> weight<180> weight<181> weight<182> weight<183> weight<184> weight<185> weight<186>
+ weight<187> weight<188> weight<189> weight<190> weight<191>
xrom_dec_inst addr<0> addr<1> addr<2> addr<3> addr<4> wl<0> wl<1> wl<2> wl<3> wl<4> wl<5> wl<6> wl<7> wl<8> wl<9> wl<10>
+ wl<11> wl<12> wl<13> wl<14> wl<15> wl<16> wl<17> wl<18> wl<19> wl<20> wl<21> wl<22> wl<23> wl<24> wl<25> wl<26>
+ wl<27> wl<28> wl<29> wl<30> wl<31> xrom_weight_dec
xrom_array_inst wl<0> wl<1> wl<2> wl<3> wl<4> wl<5> wl<6> wl<7> wl<8> wl<9> wl<10> wl<11> wl<12> wl<13> wl<14> wl<15>
+ wl<16> wl<17> wl<18> wl<19> wl<20> wl<21> wl<22> wl<23> wl<24> wl<25> wl<26> wl<27> wl<28> wl<29> wl<30> wl<31>
+ weight<0> weight<1> weight<2> weight<3> weight<4> weight<5> weight<6> weight<7> weight<8> weight<9> weight<10> weight<11> weight<12> weight<13> weight<14> weight<15>
+ weight<16> weight<17> weight<18> weight<19> weight<20> weight<21> weight<22> weight<23> weight<24> weight<25> weight<26> weight<27> weight<28> weight<29> weight<30> weight<31>
+ weight<32> weight<33> weight<34> weight<35> weight<36> weight<37> weight<38> weight<39> weight<40> weight<41> weight<42> weight<43> weight<44> weight<45> weight<46> weight<47>
+ weight<48> weight<49> weight<50> weight<51> weight<52> weight<53> weight<54> weight<55> weight<56> weight<57> weight<58> weight<59> weight<60> weight<61> weight<62> weight<63>
+ weight<64> weight<65> weight<66> weight<67> weight<68> weight<69> weight<70> weight<71> weight<72> weight<73> weight<74> weight<75> weight<76> weight<77> weight<78> weight<79>
+ weight<80> weight<81> weight<82> weight<83> weight<84> weight<85> weight<86> weight<87> weight<88> weight<89> weight<90> weight<91> weight<92> weight<93> weight<94> weight<95>
+ weight<96> weight<97> weight<98> weight<99> weight<100> weight<101> weight<102> weight<103> weight<104> weight<105> weight<106> weight<107> weight<108> weight<109> weight<110> weight<111>
+ weight<112> weight<113> weight<114> weight<115> weight<116> weight<117> weight<118> weight<119> weight<120> weight<121> weight<122> weight<123> weight<124> weight<125> weight<126> weight<127>
+ weight<128> weight<129> weight<130> weight<131> weight<132> weight<133> weight<134> weight<135> weight<136> weight<137> weight<138> weight<139> weight<140> weight<141> weight<142> weight<143>
+ weight<144> weight<145> weight<146> weight<147> weight<148> weight<149> weight<150> weight<151> weight<152> weight<153> weight<154> weight<155> weight<156> weight<157> weight<158> weight<159>
+ weight<160> weight<161> weight<162> weight<163> weight<164> weight<165> weight<166> weight<167> weight<168> weight<169> weight<170> weight<171> weight<172> weight<173> weight<174> weight<175>
+ weight<176> weight<177> weight<178> weight<179> weight<180> weight<181> weight<182> weight<183> weight<184> weight<185> weight<186> weight<187> weight<188> weight<189> weight<190> weight<191> xrom_weight_array
.ends
