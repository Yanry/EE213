** Multiplication & Addition Module

** Include VMA netlist
.INCLUDE "/home/centos/EE213/MyLibPDK45/myMAC_16_3bit_4bit/backend/pex/myMAC_16_3bit_4bit.pex.netlist"

***********************************
* Set period time here
***********************************
.PARAM
+ period = 50n

** Instantiate your MAC module here
*   The MAC module does vector inner product of two 64d vectors. The multiplier(i.e. weight) and multiplicand(i.e. input) is
*   quantized to 3bit and 4bit signed integer respectively. The output is a single 12bit signed integer.
*	The following content describes the pins needed in MAC module and the corresponding internal signals they should be connected to
*	Format:
*		<module_pin_name> -> <testbench_signal_name> : <description>
*		"->" means connect to
*
*	Your top module should have the following pins
*	Output:
*       OUT<11:0> -> result<11:0>: The output result of MAC module
*	Inputs:
*       MULTIPLIER<191:0> -> multiplier<191:0>: The 64*3bit multiplier
*       MULTIPLICAND<255:0> -> multiplicand<255:0>: The 64*4bit multiplicand

** Here is an example of the instance. The order of signals may vary with your design.
** Please connect the signals correctly. (Do not modify the instance name when you instantiate your module)
xmac VDD! GND! MULTIPLICAND<63> MULTIPLICAND<62>
+ MULTIPLICAND<59> MULTIPLICAND<58> MULTIPLICAND<55> MULTIPLICAND<54>
+ MULTIPLICAND<51> MULTIPLICAND<50> MULTIPLICAND<47> MULTIPLICAND<46>
+ MULTIPLICAND<43> MULTIPLICAND<42> MULTIPLICAND<39> MULTIPLICAND<38>
+ MULTIPLICAND<35> MULTIPLICAND<34> MULTIPLICAND<31> MULTIPLICAND<30>
+ MULTIPLICAND<27> MULTIPLICAND<26> MULTIPLICAND<23> MULTIPLICAND<22>
+ MULTIPLICAND<19> MULTIPLICAND<18> MULTIPLICAND<15> MULTIPLICAND<14>
+ MULTIPLICAND<11> MULTIPLICAND<10> MULTIPLICAND<7> MULTIPLICAND<6>
+ MULTIPLICAND<3> MULTIPLICAND<2> MULTIPLICAND<61> MULTIPLICAND<57>
+ MULTIPLICAND<53> MULTIPLICAND<49> MULTIPLICAND<45> MULTIPLICAND<41>
+ MULTIPLICAND<37> MULTIPLICAND<33> MULTIPLICAND<29> MULTIPLICAND<25>
+ MULTIPLICAND<21> MULTIPLICAND<17> MULTIPLICAND<13> MULTIPLICAND<9>
+ MULTIPLICAND<5> MULTIPLICAND<1> MULTIPLIER<45> MULTIPLIER<42> MULTIPLIER<39>
+ MULTIPLIER<36> MULTIPLIER<33> MULTIPLIER<30> MULTIPLIER<27> MULTIPLIER<24>
+ MULTIPLIER<21> MULTIPLIER<18> MULTIPLIER<15> MULTIPLIER<12> MULTIPLIER<9>
+ MULTIPLIER<6> MULTIPLIER<3> MULTIPLIER<0> MULTIPLIER<46> MULTIPLIER<43>
+ MULTIPLIER<40> MULTIPLIER<37> MULTIPLIER<34> MULTIPLIER<31> MULTIPLIER<28>
+ MULTIPLIER<25> MULTIPLIER<22> MULTIPLIER<19> MULTIPLIER<16> MULTIPLIER<13>
+ MULTIPLIER<10> MULTIPLIER<7> MULTIPLIER<4> MULTIPLIER<1> MULTIPLICAND<60>
+ MULTIPLICAND<56> MULTIPLICAND<52> MULTIPLICAND<48> MULTIPLICAND<44>
+ MULTIPLICAND<40> MULTIPLICAND<36> MULTIPLICAND<32> MULTIPLICAND<28>
+ MULTIPLICAND<24> MULTIPLICAND<20> MULTIPLICAND<16> MULTIPLICAND<12>
+ MULTIPLICAND<8> MULTIPLICAND<4> MULTIPLICAND<0> MULTIPLIER<47> MULTIPLIER<44>
+ MULTIPLIER<41> MULTIPLIER<38> MULTIPLIER<35> MULTIPLIER<32> MULTIPLIER<29>
+ MULTIPLIER<26> MULTIPLIER<23> MULTIPLIER<20> MULTIPLIER<17> MULTIPLIER<14>
+ MULTIPLIER<11> MULTIPLIER<8> MULTIPLIER<5> MULTIPLIER<2> RESULT<9> RESULT<8>
+ RESULT<7> RESULT<6> RESULT<5> RESULT<4> RESULT<3> RESULT<2> RESULT<1>
+ RESULT<0> myMAC_16_3bit_4bit
