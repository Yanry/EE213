.subckt multiplicand_src out<0> out<1> out<2> out<3> out<4> out<5> out<6> out<7> out<8> out<9> out<10> out<11> out<12> out<13> out<14> out<15>
+ out<16> out<17> out<18> out<19> out<20> out<21> out<22> out<23> out<24> out<25> out<26> out<27> out<28> out<29> out<30> out<31>
+ out<32> out<33> out<34> out<35> out<36> out<37> out<38> out<39> out<40> out<41> out<42> out<43> out<44> out<45> out<46> out<47>
+ out<48> out<49> out<50> out<51> out<52> out<53> out<54> out<55> out<56> out<57> out<58> out<59> out<60> out<61> out<62> out<63>
vpat<0> out<0> 0 PAT 'vdd_val' 0 0 0 0 'period' b1110100111011010 RB=1 R=0
vpat<1> out<1> 0 PAT 'vdd_val' 0 0 0 0 'period' b1111101110101111 RB=1 R=0
vpat<2> out<2> 0 PAT 'vdd_val' 0 0 0 0 'period' b0000111110111110 RB=1 R=0
vpat<3> out<3> 0 PAT 'vdd_val' 0 0 0 0 'period' b0001000001001110 RB=1 R=0
vpat<4> out<4> 0 PAT 'vdd_val' 0 0 0 0 'period' b1100100111100010 RB=1 R=0
vpat<5> out<5> 0 PAT 'vdd_val' 0 0 0 0 'period' b1101101101001101 RB=1 R=0
vpat<6> out<6> 0 PAT 'vdd_val' 0 0 0 0 'period' b1010100101100000 RB=1 R=0
vpat<7> out<7> 0 PAT 'vdd_val' 0 0 0 0 'period' b1110001101111101 RB=1 R=0
vpat<8> out<8> 0 PAT 'vdd_val' 0 0 0 0 'period' b0010111101000010 RB=1 R=0
vpat<9> out<9> 0 PAT 'vdd_val' 0 0 0 0 'period' b0010001011001010 RB=1 R=0
vpat<10> out<10> 0 PAT 'vdd_val' 0 0 0 0 'period' b1010011111001011 RB=1 R=0
vpat<11> out<11> 0 PAT 'vdd_val' 0 0 0 0 'period' b0110010000010100 RB=1 R=0
vpat<12> out<12> 0 PAT 'vdd_val' 0 0 0 0 'period' b0111011111110000 RB=1 R=0
vpat<13> out<13> 0 PAT 'vdd_val' 0 0 0 0 'period' b1000011100111111 RB=1 R=0
vpat<14> out<14> 0 PAT 'vdd_val' 0 0 0 0 'period' b1001101101011100 RB=1 R=0
vpat<15> out<15> 0 PAT 'vdd_val' 0 0 0 0 'period' b0111100011000111 RB=1 R=0
vpat<16> out<16> 0 PAT 'vdd_val' 0 0 0 0 'period' b0001010000111110 RB=1 R=0
vpat<17> out<17> 0 PAT 'vdd_val' 0 0 0 0 'period' b0100001001011000 RB=1 R=0
vpat<18> out<18> 0 PAT 'vdd_val' 0 0 0 0 'period' b0000011110011000 RB=1 R=0
vpat<19> out<19> 0 PAT 'vdd_val' 0 0 0 0 'period' b0010101100110110 RB=1 R=0
vpat<20> out<20> 0 PAT 'vdd_val' 0 0 0 0 'period' b0011101110010001 RB=1 R=0
vpat<21> out<21> 0 PAT 'vdd_val' 0 0 0 0 'period' b1111111000001100 RB=1 R=0
vpat<22> out<22> 0 PAT 'vdd_val' 0 0 0 0 'period' b0011010110000100 RB=1 R=0
vpat<23> out<23> 0 PAT 'vdd_val' 0 0 0 0 'period' b1101101000011000 RB=1 R=0
vpat<24> out<24> 0 PAT 'vdd_val' 0 0 0 0 'period' b0100110111101101 RB=1 R=0
vpat<25> out<25> 0 PAT 'vdd_val' 0 0 0 0 'period' b1011111111010011 RB=1 R=0
vpat<26> out<26> 0 PAT 'vdd_val' 0 0 0 0 'period' b1000001010110011 RB=1 R=0
vpat<27> out<27> 0 PAT 'vdd_val' 0 0 0 0 'period' b1010000000101111 RB=1 R=0
vpat<28> out<28> 0 PAT 'vdd_val' 0 0 0 0 'period' b1000011111000010 RB=1 R=0
vpat<29> out<29> 0 PAT 'vdd_val' 0 0 0 0 'period' b1111110011010101 RB=1 R=0
vpat<30> out<30> 0 PAT 'vdd_val' 0 0 0 0 'period' b1110100101101010 RB=1 R=0
vpat<31> out<31> 0 PAT 'vdd_val' 0 0 0 0 'period' b1110100101111010 RB=1 R=0
vpat<32> out<32> 0 PAT 'vdd_val' 0 0 0 0 'period' b0001111000111010 RB=1 R=0
vpat<33> out<33> 0 PAT 'vdd_val' 0 0 0 0 'period' b1111111011001001 RB=1 R=0
vpat<34> out<34> 0 PAT 'vdd_val' 0 0 0 0 'period' b1010010010001001 RB=1 R=0
vpat<35> out<35> 0 PAT 'vdd_val' 0 0 0 0 'period' b0110010010011000 RB=1 R=0
vpat<36> out<36> 0 PAT 'vdd_val' 0 0 0 0 'period' b1010100011000111 RB=1 R=0
vpat<37> out<37> 0 PAT 'vdd_val' 0 0 0 0 'period' b0100111101110101 RB=1 R=0
vpat<38> out<38> 0 PAT 'vdd_val' 0 0 0 0 'period' b1011110001110111 RB=1 R=0
vpat<39> out<39> 0 PAT 'vdd_val' 0 0 0 0 'period' b1001011010110001 RB=1 R=0
vpat<40> out<40> 0 PAT 'vdd_val' 0 0 0 0 'period' b1011100010100111 RB=1 R=0
vpat<41> out<41> 0 PAT 'vdd_val' 0 0 0 0 'period' b1100010001010000 RB=1 R=0
vpat<42> out<42> 0 PAT 'vdd_val' 0 0 0 0 'period' b1101010010111111 RB=1 R=0
vpat<43> out<43> 0 PAT 'vdd_val' 0 0 0 0 'period' b0101010010001110 RB=1 R=0
vpat<44> out<44> 0 PAT 'vdd_val' 0 0 0 0 'period' b0101110110101101 RB=1 R=0
vpat<45> out<45> 0 PAT 'vdd_val' 0 0 0 0 'period' b0110111000000010 RB=1 R=0
vpat<46> out<46> 0 PAT 'vdd_val' 0 0 0 0 'period' b0110010000101011 RB=1 R=0
vpat<47> out<47> 0 PAT 'vdd_val' 0 0 0 0 'period' b0011001111100010 RB=1 R=0
vpat<48> out<48> 0 PAT 'vdd_val' 0 0 0 0 'period' b1100101000111000 RB=1 R=0
vpat<49> out<49> 0 PAT 'vdd_val' 0 0 0 0 'period' b1100011100000000 RB=1 R=0
vpat<50> out<50> 0 PAT 'vdd_val' 0 0 0 0 'period' b0100010001011000 RB=1 R=0
vpat<51> out<51> 0 PAT 'vdd_val' 0 0 0 0 'period' b1100011100111011 RB=1 R=0
vpat<52> out<52> 0 PAT 'vdd_val' 0 0 0 0 'period' b1000110010111100 RB=1 R=0
vpat<53> out<53> 0 PAT 'vdd_val' 0 0 0 0 'period' b1011111100010101 RB=1 R=0
vpat<54> out<54> 0 PAT 'vdd_val' 0 0 0 0 'period' b0101001010000001 RB=1 R=0
vpat<55> out<55> 0 PAT 'vdd_val' 0 0 0 0 'period' b0111100100001111 RB=1 R=0
vpat<56> out<56> 0 PAT 'vdd_val' 0 0 0 0 'period' b1100011100101010 RB=1 R=0
vpat<57> out<57> 0 PAT 'vdd_val' 0 0 0 0 'period' b1011110001111010 RB=1 R=0
vpat<58> out<58> 0 PAT 'vdd_val' 0 0 0 0 'period' b0100111010111110 RB=1 R=0
vpat<59> out<59> 0 PAT 'vdd_val' 0 0 0 0 'period' b0110000111110011 RB=1 R=0
vpat<60> out<60> 0 PAT 'vdd_val' 0 0 0 0 'period' b1111000001100111 RB=1 R=0
vpat<61> out<61> 0 PAT 'vdd_val' 0 0 0 0 'period' b1101100111101111 RB=1 R=0
vpat<62> out<62> 0 PAT 'vdd_val' 0 0 0 0 'period' b1011111101001110 RB=1 R=0
vpat<63> out<63> 0 PAT 'vdd_val' 0 0 0 0 'period' b1111010101101001 RB=1 R=0
.ends multiplicand_src
