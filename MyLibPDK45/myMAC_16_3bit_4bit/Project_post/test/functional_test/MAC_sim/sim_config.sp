** Params
.GLOBAL vdd!
.PARAM vdd_val=0.7 period=5n

.TRAN 1e-12 'period*32' START=0.0

.TEMP 25.0
.OPTION
+    INGOLD=2
+    PARHIER=LOCAL
+    PROBE
+    NOMOD
+    POST=2

.PROBE TRAN
+    V(multiplier<0>)
+    V(multiplier<1>)
+    V(multiplier<2>)
+    V(multiplier<3>)
+    V(multiplier<4>)
+    V(multiplier<5>)
+    V(multiplier<6>)
+    V(multiplier<7>)
+    V(multiplier<8>)
+    V(multiplier<9>)
+    V(multiplier<10>)
+    V(multiplier<11>)
+    V(multiplier<12>)
+    V(multiplier<13>)
+    V(multiplier<14>)
+    V(multiplier<15>)
+    V(multiplier<16>)
+    V(multiplier<17>)
+    V(multiplier<18>)
+    V(multiplier<19>)
+    V(multiplier<20>)
+    V(multiplier<21>)
+    V(multiplier<22>)
+    V(multiplier<23>)
+    V(multiplier<24>)
+    V(multiplier<25>)
+    V(multiplier<26>)
+    V(multiplier<27>)
+    V(multiplier<28>)
+    V(multiplier<29>)
+    V(multiplier<30>)
.PROBE TRAN
+    V(multiplier<31>)
+    V(multiplier<32>)
+    V(multiplier<33>)
+    V(multiplier<34>)
+    V(multiplier<35>)
+    V(multiplier<36>)
+    V(multiplier<37>)
+    V(multiplier<38>)
+    V(multiplier<39>)
+    V(multiplier<40>)
+    V(multiplier<41>)
+    V(multiplier<42>)
+    V(multiplier<43>)
+    V(multiplier<44>)
+    V(multiplier<45>)
+    V(multiplier<46>)
+    V(multiplier<47>)
.PROBE TRAN
+    V(multiplicand<0>)
+    V(multiplicand<1>)
+    V(multiplicand<2>)
+    V(multiplicand<3>)
+    V(multiplicand<4>)
+    V(multiplicand<5>)
+    V(multiplicand<6>)
+    V(multiplicand<7>)
+    V(multiplicand<8>)
+    V(multiplicand<9>)
+    V(multiplicand<10>)
+    V(multiplicand<11>)
+    V(multiplicand<12>)
+    V(multiplicand<13>)
+    V(multiplicand<14>)
+    V(multiplicand<15>)
+    V(multiplicand<16>)
+    V(multiplicand<17>)
+    V(multiplicand<18>)
+    V(multiplicand<19>)
+    V(multiplicand<20>)
+    V(multiplicand<21>)
+    V(multiplicand<22>)
+    V(multiplicand<23>)
+    V(multiplicand<24>)
+    V(multiplicand<25>)
+    V(multiplicand<26>)
+    V(multiplicand<27>)
+    V(multiplicand<28>)
+    V(multiplicand<29>)
+    V(multiplicand<30>)
.PROBE TRAN
+    V(multiplicand<31>)
+    V(multiplicand<32>)
+    V(multiplicand<33>)
+    V(multiplicand<34>)
+    V(multiplicand<35>)
+    V(multiplicand<36>)
+    V(multiplicand<37>)
+    V(multiplicand<38>)
+    V(multiplicand<39>)
+    V(multiplicand<40>)
+    V(multiplicand<41>)
+    V(multiplicand<42>)
+    V(multiplicand<43>)
+    V(multiplicand<44>)
+    V(multiplicand<45>)
+    V(multiplicand<46>)
+    V(multiplicand<47>)
+    V(multiplicand<48>)
+    V(multiplicand<49>)
+    V(multiplicand<50>)
+    V(multiplicand<51>)
+    V(multiplicand<52>)
+    V(multiplicand<53>)
+    V(multiplicand<54>)
+    V(multiplicand<55>)
+    V(multiplicand<56>)
+    V(multiplicand<57>)
+    V(multiplicand<58>)
+    V(multiplicand<59>)
+    V(multiplicand<60>)
+    V(multiplicand<61>)
+    V(multiplicand<62>)
.PROBE TRAN
+    V(multiplicand<63>)
.PROBE TRAN
+    V(result<0>)
+    V(result<1>)
+    V(result<2>)
+    V(result<3>)
+    V(result<4>)
+    V(result<5>)
+    V(result<6>)
+    V(result<7>)
+    V(result<8>)
+    V(result<9>)
+    V(clk)
