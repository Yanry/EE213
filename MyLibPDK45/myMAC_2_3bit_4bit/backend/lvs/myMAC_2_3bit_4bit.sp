* SPICE NETLIST
***************************************

.SUBCKT myNAND A gnd! B Z vdd!
** N=6 EP=5 IP=0 FDC=4
M0 6 A gnd! gnd! NMOS_VTL L=5e-08 W=9e-08 AD=1.35e-14 AS=1.08e-14 PD=4.8e-07 PS=4.2e-07 $X=20 $Y=80 $D=1
M1 Z B 6 gnd! NMOS_VTL L=5e-08 W=9e-08 AD=1.08e-14 AS=1.35e-14 PD=4.2e-07 PS=4.8e-07 $X=420 $Y=80 $D=1
M2 Z A vdd! vdd! PMOS_VTL L=5e-08 W=1.8e-07 AD=2.7e-14 AS=2.16e-14 PD=6.6e-07 PS=6e-07 $X=20 $Y=930 $D=0
M3 vdd! B Z vdd! PMOS_VTL L=5e-08 W=1.8e-07 AD=2.16e-14 AS=2.7e-14 PD=6e-07 PS=6.6e-07 $X=420 $Y=930 $D=0
.ENDS
***************************************
.SUBCKT myNMOS 1 2 3 4
** N=4 EP=4 IP=0 FDC=1
M0 3 4 2 1 NMOS_VTL L=5e-08 W=9e-08 AD=1.08e-14 AS=1.08e-14 PD=4.2e-07 PS=4.2e-07 $X=40 $Y=-45 $D=1
.ENDS
***************************************
.SUBCKT myPMOS 1 2 3 4
** N=4 EP=4 IP=0 FDC=1
M0 3 4 2 1 PMOS_VTL L=5e-08 W=1.8e-07 AD=2.16e-14 AS=2.16e-14 PD=6e-07 PS=6e-07 $X=85 $Y=-185 $D=0
.ENDS
***************************************
.SUBCKT myInverter45 in gnd! vdd! out
** N=4 EP=4 IP=8 FDC=2
X0 gnd! gnd! out in myNMOS $T=100 -545 0 0 $X=-550 $Y=-735
X1 vdd! vdd! out in myPMOS $T=55 445 0 0 $X=-550 $Y=120
.ENDS
***************************************
.SUBCKT myAnd gnd! vdd! A B Z
** N=6 EP=5 IP=9 FDC=6
X0 A gnd! B 6 vdd! myNAND $T=1015 1170 0 0 $X=345 $Y=920
X1 6 gnd! vdd! Z myInverter45 $T=2815 1840 0 0 $X=2265 $Y=920
.ENDS
***************************************
.SUBCKT myHA gnd! vdd! Cout B A S
** N=8 EP=6 IP=17 FDC=12
M0 8 B gnd! gnd! NMOS_VTL L=5e-08 W=9e-08 AD=1.08e-14 AS=1.08e-14 PD=4.2e-07 PS=4.2e-07 $X=-1310 $Y=-1155 $D=1
M1 S A 8 gnd! NMOS_VTL L=5e-08 W=9e-08 AD=1.08e-14 AS=1.08e-14 PD=4.2e-07 PS=4.2e-07 $X=300 $Y=-1155 $D=1
M2 8 B vdd! vdd! PMOS_VTL L=5e-08 W=1.8e-07 AD=2.16e-14 AS=2.16e-14 PD=6e-07 PS=6e-07 $X=-1310 $Y=-255 $D=0
M3 S A B vdd! PMOS_VTL L=5e-08 W=1.8e-07 AD=2.16e-14 AS=2.16e-14 PD=6e-07 PS=6e-07 $X=300 $Y=-255 $D=0
X4 A gnd! B 7 vdd! myNAND $T=-2965 -1175 1 180 $X=-3835 $Y=-1425
X5 gnd! S A 8 myNMOS $T=1870 -1105 0 0 $X=1220 $Y=-1295
X6 vdd! S A B myPMOS $T=1825 -70 0 0 $X=1220 $Y=-395
X7 7 gnd! vdd! Cout myInverter45 $T=-4655 -505 1 180 $X=-5265 $Y=-1425
.ENDS
***************************************
.SUBCKT myFA A B Cin gnd! vdd! Cout S
** N=19 EP=7 IP=8 FDC=28
M0 9 A gnd! gnd! NMOS_VTL L=5e-08 W=9e-08 AD=1.35e-14 AS=1.08e-14 PD=4.8e-07 PS=4.2e-07 $X=-255 $Y=-530 $D=1
M1 gnd! B 9 gnd! NMOS_VTL L=5e-08 W=9e-08 AD=1.08e-14 AS=1.35e-14 PD=4.2e-07 PS=4.8e-07 $X=145 $Y=-530 $D=1
M2 8 Cin 9 gnd! NMOS_VTL L=5e-08 W=9e-08 AD=1.08e-14 AS=1.08e-14 PD=4.2e-07 PS=4.2e-07 $X=885 $Y=-530 $D=1
M3 17 A 8 gnd! NMOS_VTL L=5e-08 W=9e-08 AD=1.35e-14 AS=1.08e-14 PD=4.8e-07 PS=4.2e-07 $X=1625 $Y=-530 $D=1
M4 gnd! B 17 gnd! NMOS_VTL L=5e-08 W=9e-08 AD=1.08e-14 AS=1.35e-14 PD=4.2e-07 PS=4.8e-07 $X=2025 $Y=-530 $D=1
M5 11 A gnd! gnd! NMOS_VTL L=5e-08 W=9e-08 AD=1.35e-14 AS=1.08e-14 PD=4.8e-07 PS=4.2e-07 $X=3930 $Y=-530 $D=1
M6 gnd! B 11 gnd! NMOS_VTL L=5e-08 W=9e-08 AD=1.35e-14 AS=1.35e-14 PD=4.8e-07 PS=4.8e-07 $X=4330 $Y=-530 $D=1
M7 11 Cin gnd! gnd! NMOS_VTL L=5e-08 W=9e-08 AD=1.08e-14 AS=1.35e-14 PD=4.2e-07 PS=4.8e-07 $X=4730 $Y=-530 $D=1
M8 13 8 11 gnd! NMOS_VTL L=5e-08 W=9e-08 AD=1.08e-14 AS=1.08e-14 PD=4.2e-07 PS=4.2e-07 $X=5470 $Y=-530 $D=1
M9 18 Cin 13 gnd! NMOS_VTL L=5e-08 W=9e-08 AD=1.35e-14 AS=1.08e-14 PD=4.8e-07 PS=4.2e-07 $X=6210 $Y=-530 $D=1
M10 19 A 18 gnd! NMOS_VTL L=5e-08 W=9e-08 AD=1.35e-14 AS=1.35e-14 PD=4.8e-07 PS=4.8e-07 $X=6610 $Y=-530 $D=1
M11 gnd! B 19 gnd! NMOS_VTL L=5e-08 W=9e-08 AD=1.08e-14 AS=1.35e-14 PD=4.2e-07 PS=4.8e-07 $X=7010 $Y=-530 $D=1
M12 10 A vdd! vdd! PMOS_VTL L=5e-08 W=1.8e-07 AD=2.7e-14 AS=2.16e-14 PD=6.6e-07 PS=6e-07 $X=-255 $Y=320 $D=0
M13 vdd! B 10 vdd! PMOS_VTL L=5e-08 W=1.8e-07 AD=2.16e-14 AS=2.7e-14 PD=6e-07 PS=6.6e-07 $X=145 $Y=320 $D=0
M14 8 Cin 10 vdd! PMOS_VTL L=5e-08 W=1.8e-07 AD=2.16e-14 AS=2.16e-14 PD=6e-07 PS=6e-07 $X=885 $Y=320 $D=0
M15 14 A 8 vdd! PMOS_VTL L=5e-08 W=1.8e-07 AD=2.7e-14 AS=2.16e-14 PD=6.6e-07 PS=6e-07 $X=1625 $Y=320 $D=0
M16 vdd! B 14 vdd! PMOS_VTL L=5e-08 W=1.8e-07 AD=2.16e-14 AS=2.7e-14 PD=6e-07 PS=6.6e-07 $X=2025 $Y=320 $D=0
M17 12 A vdd! vdd! PMOS_VTL L=5e-08 W=1.8e-07 AD=2.7e-14 AS=2.16e-14 PD=6.6e-07 PS=6e-07 $X=3930 $Y=320 $D=0
M18 vdd! B 12 vdd! PMOS_VTL L=5e-08 W=1.8e-07 AD=2.7e-14 AS=2.7e-14 PD=6.6e-07 PS=6.6e-07 $X=4330 $Y=320 $D=0
M19 12 Cin vdd! vdd! PMOS_VTL L=5e-08 W=1.8e-07 AD=2.16e-14 AS=2.7e-14 PD=6e-07 PS=6.6e-07 $X=4730 $Y=320 $D=0
M20 13 8 12 vdd! PMOS_VTL L=5e-08 W=1.8e-07 AD=2.16e-14 AS=2.16e-14 PD=6e-07 PS=6e-07 $X=5470 $Y=320 $D=0
M21 15 Cin 13 vdd! PMOS_VTL L=5e-08 W=1.8e-07 AD=2.7e-14 AS=2.16e-14 PD=6.6e-07 PS=6e-07 $X=6210 $Y=320 $D=0
M22 16 A 15 vdd! PMOS_VTL L=5e-08 W=1.8e-07 AD=2.7e-14 AS=2.7e-14 PD=6.6e-07 PS=6.6e-07 $X=6610 $Y=320 $D=0
M23 vdd! B 16 vdd! PMOS_VTL L=5e-08 W=1.8e-07 AD=2.16e-14 AS=2.7e-14 PD=6e-07 PS=6.6e-07 $X=7010 $Y=320 $D=0
X24 8 gnd! vdd! Cout myInverter45 $T=3050 60 0 0 $X=2500 $Y=-860
X25 13 gnd! vdd! S myInverter45 $T=7950 60 0 0 $X=7400 $Y=-860
.ENDS
***************************************
.SUBCKT myPPA_4_3 gnd! vdd! A1<3> A0<3> S<1> A0<2> A1<2> A1<1> A0<1> A1<0> A0<0> A2<2> S<0> A2<3> A2<0> A2<1> S<5> S<4> S<2> S<3>
** N=45 EP=20 IP=106 FDC=254
X0 A1<3> gnd! vdd! 28 myInverter45 $T=-11550 -5615 0 0 $X=-12100 $Y=-6535
X1 A0<3> gnd! vdd! 29 myInverter45 $T=-11550 -2560 0 0 $X=-12100 $Y=-3480
X2 A0<0> gnd! vdd! 32 myInverter45 $T=-1815 3030 0 0 $X=-2365 $Y=2110
X3 A2<2> gnd! vdd! 33 myInverter45 $T=-1720 -5615 0 0 $X=-2270 $Y=-6535
X4 32 gnd! vdd! S<0> myInverter45 $T=-385 3030 0 0 $X=-935 $Y=2110
X5 A2<0> gnd! vdd! 39 myInverter45 $T=9295 3020 1 180 $X=8685 $Y=2100
X6 A2<1> gnd! vdd! 36 myInverter45 $T=10865 3020 1 180 $X=10255 $Y=2100
X7 gnd! vdd! 38 28 21 30 myHA $T=-8235 -5110 1 180 $X=-10615 $Y=-6695
X8 gnd! vdd! 31 A1<0> A0<1> S<1> myHA $T=-8235 3535 1 180 $X=-10615 $Y=1950
X9 gnd! vdd! 35 34 39 41 myHA $T=5905 3535 0 0 $X=640 $Y=1950
X10 gnd! vdd! 45 42 25 S<5> myHA $T=14995 -5110 0 0 $X=9730 $Y=-6695
X11 gnd! vdd! 25 43 27 S<4> myHA $T=14995 -2055 0 0 $X=9730 $Y=-3640
X12 gnd! vdd! 26 41 vdd! S<2> myHA $T=17075 3525 0 0 $X=11810 $Y=1940
X13 22 29 A1<2> gnd! vdd! 21 37 myFA $T=-9670 -2620 0 0 $X=-10615 $Y=-4000
X14 31 A0<2> A1<1> gnd! vdd! 22 34 myFA $T=-9670 435 0 0 $X=-10615 $Y=-945
X15 23 A2<3> 38 gnd! vdd! 40 42 myFA $T=380 -5675 0 0 $X=-565 $Y=-7055
X16 24 33 30 gnd! vdd! 23 43 myFA $T=380 -2620 0 0 $X=-565 $Y=-4000
X17 35 36 37 gnd! vdd! 24 44 myFA $T=380 435 0 0 $X=-565 $Y=-945
X18 26 vdd! 44 gnd! vdd! 27 S<3> myFA $T=10480 435 0 0 $X=9535 $Y=-945
.ENDS
***************************************
.SUBCKT myMulti_3bit_4bit vdd! gnd! MULTIPLICAND<2> MULTIPLICAND<3> MULTIPLIER<1> MULTIPLICAND<1> MULTIPLIER<0> S<1> MULTIPLICAND<0> S<0> MULTIPLIER<2> S<5> S<4> S<2> S<3>
** N=27 EP=15 IP=80 FDC=326
X0 gnd! vdd! MULTIPLICAND<2> MULTIPLIER<1> 16 myAnd $T=-36665 -6215 0 90 $X=-39465 $Y=-5870
X1 gnd! vdd! MULTIPLICAND<1> MULTIPLIER<1> 17 myAnd $T=-36665 -2750 0 90 $X=-39465 $Y=-2405
X2 gnd! vdd! MULTIPLICAND<3> MULTIPLIER<0> 22 myAnd $T=-39505 540 0 0 $X=-39160 $Y=1460
X3 gnd! vdd! MULTIPLICAND<2> MULTIPLIER<0> 23 myAnd $T=-39505 3010 0 0 $X=-39160 $Y=3930
X4 gnd! vdd! MULTIPLICAND<3> MULTIPLIER<1> 24 myAnd $T=-37345 -8290 0 0 $X=-37000 $Y=-7370
X5 gnd! vdd! MULTIPLICAND<1> MULTIPLIER<0> 25 myAnd $T=-36790 5785 0 0 $X=-36445 $Y=6705
X6 gnd! vdd! MULTIPLICAND<2> MULTIPLIER<2> 19 myAnd $T=-33285 -8290 0 0 $X=-32940 $Y=-7370
X7 gnd! vdd! MULTIPLICAND<0> MULTIPLIER<0> 18 myAnd $T=-29235 5785 1 180 $X=-32660 $Y=6705
X8 gnd! vdd! MULTIPLICAND<3> MULTIPLIER<2> 27 myAnd $T=-29565 -8290 0 0 $X=-29220 $Y=-7370
X9 gnd! vdd! MULTIPLICAND<0> MULTIPLIER<1> 26 myAnd $T=-25675 5785 1 180 $X=-29100 $Y=6705
X10 gnd! vdd! MULTIPLICAND<0> MULTIPLIER<2> 20 myAnd $T=-25640 5785 0 0 $X=-25295 $Y=6705
X11 gnd! vdd! MULTIPLICAND<1> MULTIPLIER<2> 21 myAnd $T=-21725 5785 0 0 $X=-21380 $Y=6705
X12 gnd! vdd! 24 22 S<1> 23 16 17 25 26 18 19 S<0> 27 20 21 S<5> S<4> S<2> S<3> myPPA_4_3 $T=-24540 1885 0 0 $X=-36900 $Y=-5465
.ENDS
***************************************
.SUBCKT myMAC_2_3bit_4bit gnd! MULTIPLICAND<7> MULTIPLICAND<6> MULTIPLICAND<3> MULTIPLICAND<2> vdd! MULTIPLICAND<5> MULTIPLICAND<1> MULTIPLIER<3> MULTIPLIER<0> MULTIPLIER<1> MULTIPLIER<4> MULTIPLICAND<4> MULTIPLICAND<0> MULTIPLIER<5> MULTIPLIER<2> S<6> S<5> S<4> S<3>
+ S<2> S<1> S<0>
** N=42 EP=23 IP=79 FDC=848
X0 14 7 5 gnd! vdd! 42 S<6> myFA $T=-6440 -10680 0 0 $X=-7385 $Y=-12060
X1 15 7 5 gnd! vdd! 14 S<5> myFA $T=-6440 -7490 0 0 $X=-7385 $Y=-8870
X2 16 8 6 gnd! vdd! 15 S<4> myFA $T=-6440 -4300 0 0 $X=-7385 $Y=-5680
X3 17 10 9 gnd! vdd! 16 S<3> myFA $T=-6440 -1110 0 0 $X=-7385 $Y=-2490
X4 18 12 11 gnd! vdd! 17 S<2> myFA $T=-6440 2080 0 0 $X=-7385 $Y=700
X5 19 2 1 gnd! vdd! 18 S<1> myFA $T=-6440 5270 0 0 $X=-7385 $Y=3890
X6 gnd! 4 3 gnd! vdd! 19 S<0> myFA $T=-6440 8460 0 0 $X=-7385 $Y=7080
X7 vdd! gnd! MULTIPLICAND<6> MULTIPLICAND<7> MULTIPLIER<4> MULTIPLICAND<5> MULTIPLIER<3> 1 MULTIPLICAND<4> 3 MULTIPLIER<5> 5 6 11 9 myMulti_3bit_4bit $T=-4485 -12120 0 0 $X=-44265 $Y=-19845
X8 vdd! gnd! MULTIPLICAND<2> MULTIPLICAND<3> MULTIPLIER<1> MULTIPLICAND<1> MULTIPLIER<0> 2 MULTIPLICAND<0> 4 MULTIPLIER<2> 7 8 12 10 myMulti_3bit_4bit $T=-4485 5940 0 0 $X=-44265 $Y=-1785
.ENDS
***************************************
