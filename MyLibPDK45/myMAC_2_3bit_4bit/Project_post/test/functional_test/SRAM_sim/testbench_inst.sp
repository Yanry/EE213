** SRAM functional test

** SRAM precharge
v7 prc 0 PULSE vdd_val 0 0 0 0 SRAM_PRC_LOW_DURATION period

** test
xdata data<0> data<1> data<2> data<3> data<4> data<5> data<6> data<7> data<8> data<9> data<10>
+ data<11> data<12> data<13> data<14> data<15> data<16> data<17> data<18> data<19> data<20> data<21> data<22> data<23> data<24> data<25> data<26>
+ data<27> data<28> data<29> data<30> data<31> data<32> data<33> data<34> data<35> data<36> data<37> data<38> data<39> data<40> data<41> data<42>
+ data<43> data<44> data<45> data<46> data<47> data<48> data<49> data<50> data<51> data<52> data<53> data<54> data<55> data<56> data<57> data<58>
+ data<59> data<60> data<61> data<62> data<63> data<64> data<65> data<66> data<67> data<68> data<69> data<70> data<71> data<72> data<73> data<74>
+ data<75> data<76> data<77> data<78> data<79> data<80> data<81> data<82> data<83> data<84> data<85> data<86> data<87> data<88> data<89> data<90>
+ data<91> data<92> data<93> data<94> data<95> data<96> data<97> data<98> data<99> data<100> data<101> data<102> data<103> data<104> data<105> data<106>
+ data<107> data<108> data<109> data<110> data<111> data<112> data<113> data<114> data<115> data<116> data<117> data<118> data<119> data<120> data<121> data<122>
+ data<123> data<124> data<125> data<126> data<127> data<128> data<129> data<130> data<131> data<132> data<133> data<134> data<135> data<136> data<137> data<138>
+ data<139> data<140> data<141> data<142> data<143> data<144> data<145> data<146> data<147> data<148> data<149> data<150> data<151> data<152> data<153> data<154>
+ data<155> data<156> data<157> data<158> data<159> data<160> data<161> data<162> data<163> data<164> data<165> data<166> data<167> data<168> data<169> data<170>
+ data<171> data<172> data<173> data<174> data<175> data<176> data<177> data<178> data<179> data<180> data<181> data<182> data<183> data<184> data<185> data<186>
+ data<187> data<188> data<189> data<190> data<191> input_src vdd_val=vdd_val period=period

** Library name: mycells45
** Cell name: SRAM_192bit_32_test
** View name: schematic
c0<191> data_read<191> 0 40e-15
c0<190> data_read<190> 0 40e-15
c0<189> data_read<189> 0 40e-15
c0<188> data_read<188> 0 40e-15
c0<187> data_read<187> 0 40e-15
c0<186> data_read<186> 0 40e-15
c0<185> data_read<185> 0 40e-15
c0<184> data_read<184> 0 40e-15
c0<183> data_read<183> 0 40e-15
c0<182> data_read<182> 0 40e-15
c0<181> data_read<181> 0 40e-15
c0<180> data_read<180> 0 40e-15
c0<179> data_read<179> 0 40e-15
c0<178> data_read<178> 0 40e-15
c0<177> data_read<177> 0 40e-15
c0<176> data_read<176> 0 40e-15
c0<175> data_read<175> 0 40e-15
c0<174> data_read<174> 0 40e-15
c0<173> data_read<173> 0 40e-15
c0<172> data_read<172> 0 40e-15
c0<171> data_read<171> 0 40e-15
c0<170> data_read<170> 0 40e-15
c0<169> data_read<169> 0 40e-15
c0<168> data_read<168> 0 40e-15
c0<167> data_read<167> 0 40e-15
c0<166> data_read<166> 0 40e-15
c0<165> data_read<165> 0 40e-15
c0<164> data_read<164> 0 40e-15
c0<163> data_read<163> 0 40e-15
c0<162> data_read<162> 0 40e-15
c0<161> data_read<161> 0 40e-15
c0<160> data_read<160> 0 40e-15
c0<159> data_read<159> 0 40e-15
c0<158> data_read<158> 0 40e-15
c0<157> data_read<157> 0 40e-15
c0<156> data_read<156> 0 40e-15
c0<155> data_read<155> 0 40e-15
c0<154> data_read<154> 0 40e-15
c0<153> data_read<153> 0 40e-15
c0<152> data_read<152> 0 40e-15
c0<151> data_read<151> 0 40e-15
c0<150> data_read<150> 0 40e-15
c0<149> data_read<149> 0 40e-15
c0<148> data_read<148> 0 40e-15
c0<147> data_read<147> 0 40e-15
c0<146> data_read<146> 0 40e-15
c0<145> data_read<145> 0 40e-15
c0<144> data_read<144> 0 40e-15
c0<143> data_read<143> 0 40e-15
c0<142> data_read<142> 0 40e-15
c0<141> data_read<141> 0 40e-15
c0<140> data_read<140> 0 40e-15
c0<139> data_read<139> 0 40e-15
c0<138> data_read<138> 0 40e-15
c0<137> data_read<137> 0 40e-15
c0<136> data_read<136> 0 40e-15
c0<135> data_read<135> 0 40e-15
c0<134> data_read<134> 0 40e-15
c0<133> data_read<133> 0 40e-15
c0<132> data_read<132> 0 40e-15
c0<131> data_read<131> 0 40e-15
c0<130> data_read<130> 0 40e-15
c0<129> data_read<129> 0 40e-15
c0<128> data_read<128> 0 40e-15
c0<127> data_read<127> 0 40e-15
c0<126> data_read<126> 0 40e-15
c0<125> data_read<125> 0 40e-15
c0<124> data_read<124> 0 40e-15
c0<123> data_read<123> 0 40e-15
c0<122> data_read<122> 0 40e-15
c0<121> data_read<121> 0 40e-15
c0<120> data_read<120> 0 40e-15
c0<119> data_read<119> 0 40e-15
c0<118> data_read<118> 0 40e-15
c0<117> data_read<117> 0 40e-15
c0<116> data_read<116> 0 40e-15
c0<115> data_read<115> 0 40e-15
c0<114> data_read<114> 0 40e-15
c0<113> data_read<113> 0 40e-15
c0<112> data_read<112> 0 40e-15
c0<111> data_read<111> 0 40e-15
c0<110> data_read<110> 0 40e-15
c0<109> data_read<109> 0 40e-15
c0<108> data_read<108> 0 40e-15
c0<107> data_read<107> 0 40e-15
c0<106> data_read<106> 0 40e-15
c0<105> data_read<105> 0 40e-15
c0<104> data_read<104> 0 40e-15
c0<103> data_read<103> 0 40e-15
c0<102> data_read<102> 0 40e-15
c0<101> data_read<101> 0 40e-15
c0<100> data_read<100> 0 40e-15
c0<99> data_read<99> 0 40e-15
c0<98> data_read<98> 0 40e-15
c0<97> data_read<97> 0 40e-15
c0<96> data_read<96> 0 40e-15
c0<95> data_read<95> 0 40e-15
c0<94> data_read<94> 0 40e-15
c0<93> data_read<93> 0 40e-15
c0<92> data_read<92> 0 40e-15
c0<91> data_read<91> 0 40e-15
c0<90> data_read<90> 0 40e-15
c0<89> data_read<89> 0 40e-15
c0<88> data_read<88> 0 40e-15
c0<87> data_read<87> 0 40e-15
c0<86> data_read<86> 0 40e-15
c0<85> data_read<85> 0 40e-15
c0<84> data_read<84> 0 40e-15
c0<83> data_read<83> 0 40e-15
c0<82> data_read<82> 0 40e-15
c0<81> data_read<81> 0 40e-15
c0<80> data_read<80> 0 40e-15
c0<79> data_read<79> 0 40e-15
c0<78> data_read<78> 0 40e-15
c0<77> data_read<77> 0 40e-15
c0<76> data_read<76> 0 40e-15
c0<75> data_read<75> 0 40e-15
c0<74> data_read<74> 0 40e-15
c0<73> data_read<73> 0 40e-15
c0<72> data_read<72> 0 40e-15
c0<71> data_read<71> 0 40e-15
c0<70> data_read<70> 0 40e-15
c0<69> data_read<69> 0 40e-15
c0<68> data_read<68> 0 40e-15
c0<67> data_read<67> 0 40e-15
c0<66> data_read<66> 0 40e-15
c0<65> data_read<65> 0 40e-15
c0<64> data_read<64> 0 40e-15
c0<63> data_read<63> 0 40e-15
c0<62> data_read<62> 0 40e-15
c0<61> data_read<61> 0 40e-15
c0<60> data_read<60> 0 40e-15
c0<59> data_read<59> 0 40e-15
c0<58> data_read<58> 0 40e-15
c0<57> data_read<57> 0 40e-15
c0<56> data_read<56> 0 40e-15
c0<55> data_read<55> 0 40e-15
c0<54> data_read<54> 0 40e-15
c0<53> data_read<53> 0 40e-15
c0<52> data_read<52> 0 40e-15
c0<51> data_read<51> 0 40e-15
c0<50> data_read<50> 0 40e-15
c0<49> data_read<49> 0 40e-15
c0<48> data_read<48> 0 40e-15
c0<47> data_read<47> 0 40e-15
c0<46> data_read<46> 0 40e-15
c0<45> data_read<45> 0 40e-15
c0<44> data_read<44> 0 40e-15
c0<43> data_read<43> 0 40e-15
c0<42> data_read<42> 0 40e-15
c0<41> data_read<41> 0 40e-15
c0<40> data_read<40> 0 40e-15
c0<39> data_read<39> 0 40e-15
c0<38> data_read<38> 0 40e-15
c0<37> data_read<37> 0 40e-15
c0<36> data_read<36> 0 40e-15
c0<35> data_read<35> 0 40e-15
c0<34> data_read<34> 0 40e-15
c0<33> data_read<33> 0 40e-15
c0<32> data_read<32> 0 40e-15
c0<31> data_read<31> 0 40e-15
c0<30> data_read<30> 0 40e-15
c0<29> data_read<29> 0 40e-15
c0<28> data_read<28> 0 40e-15
c0<27> data_read<27> 0 40e-15
c0<26> data_read<26> 0 40e-15
c0<25> data_read<25> 0 40e-15
c0<24> data_read<24> 0 40e-15
c0<23> data_read<23> 0 40e-15
c0<22> data_read<22> 0 40e-15
c0<21> data_read<21> 0 40e-15
c0<20> data_read<20> 0 40e-15
c0<19> data_read<19> 0 40e-15
c0<18> data_read<18> 0 40e-15
c0<17> data_read<17> 0 40e-15
c0<16> data_read<16> 0 40e-15
c0<15> data_read<15> 0 40e-15
c0<14> data_read<14> 0 40e-15
c0<13> data_read<13> 0 40e-15
c0<12> data_read<12> 0 40e-15
c0<11> data_read<11> 0 40e-15
c0<10> data_read<10> 0 40e-15
c0<9> data_read<9> 0 40e-15
c0<8> data_read<8> 0 40e-15
c0<7> data_read<7> 0 40e-15
c0<6> data_read<6> 0 40e-15
c0<5> data_read<5> 0 40e-15
c0<4> data_read<4> 0 40e-15
c0<3> data_read<3> 0 40e-15
c0<2> data_read<2> 0 40e-15
c0<1> data_read<1> 0 40e-15
c0<0> data_read<0> 0 40e-15
v6 sram_wen 0 PULSE 0 vdd_val 0 0 0 'period*32' 'period*64'
v5 sram_ren 0 PULSE vdd_val 0 0 0 0 'period*32' 'period*64'
v4 addr<4> 0 PULSE vdd_val 0 0 0 0 'period*16' 'period*32'
v3 addr<3> 0 PULSE vdd_val 0 0 0 0 'period*8' 'period*16'
v2 addr<2> 0 PULSE vdd_val 0 0 0 0 'period*4' 'period*8'
v1 addr<1> 0 PULSE vdd_val 0 0 0 0 'period*2' 'period*4'
v0 addr<0> 0 PULSE vdd_val 0 0 0 0 'period*1' 'period*2'
v8 vdd! 0 DC=vdd_val
